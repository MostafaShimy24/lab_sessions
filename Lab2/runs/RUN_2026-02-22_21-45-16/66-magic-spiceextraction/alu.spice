* NGSPICE file created from alu.ext - technology: sky130A

* Black-box entry subcircuit for sky130_ef_sc_hd__decap_12 abstract view
.subckt sky130_ef_sc_hd__decap_12 VPWR VGND VPB VNB
.ends

* Black-box entry subcircuit for sky130_fd_sc_hd__fill_1 abstract view
.subckt sky130_fd_sc_hd__fill_1 VGND VNB VPB VPWR
.ends

* Black-box entry subcircuit for sky130_fd_sc_hd__tapvpwrvgnd_1 abstract view
.subckt sky130_fd_sc_hd__tapvpwrvgnd_1 VGND VPWR
.ends

* Black-box entry subcircuit for sky130_fd_sc_hd__decap_6 abstract view
.subckt sky130_fd_sc_hd__decap_6 VGND VNB VPB VPWR
.ends

* Black-box entry subcircuit for sky130_fd_sc_hd__and4_1 abstract view
.subckt sky130_fd_sc_hd__and4_1 A B C D VGND VNB VPB VPWR X
.ends

* Black-box entry subcircuit for sky130_fd_sc_hd__decap_4 abstract view
.subckt sky130_fd_sc_hd__decap_4 VGND VNB VPB VPWR
.ends

* Black-box entry subcircuit for sky130_fd_sc_hd__or2_1 abstract view
.subckt sky130_fd_sc_hd__or2_1 A B VGND VNB VPB VPWR X
.ends

* Black-box entry subcircuit for sky130_fd_sc_hd__fill_2 abstract view
.subckt sky130_fd_sc_hd__fill_2 VGND VNB VPB VPWR
.ends

* Black-box entry subcircuit for sky130_fd_sc_hd__xnor2_1 abstract view
.subckt sky130_fd_sc_hd__xnor2_1 A B VGND VNB VPB VPWR Y
.ends

* Black-box entry subcircuit for sky130_fd_sc_hd__nand3_2 abstract view
.subckt sky130_fd_sc_hd__nand3_2 A B C VGND VNB VPB VPWR Y
.ends

* Black-box entry subcircuit for sky130_fd_sc_hd__decap_3 abstract view
.subckt sky130_fd_sc_hd__decap_3 VGND VNB VPB VPWR
.ends

* Black-box entry subcircuit for sky130_fd_sc_hd__nand2_1 abstract view
.subckt sky130_fd_sc_hd__nand2_1 A B VGND VNB VPB VPWR Y
.ends

* Black-box entry subcircuit for sky130_fd_sc_hd__a31o_1 abstract view
.subckt sky130_fd_sc_hd__a31o_1 A1 A2 A3 B1 VGND VNB VPB VPWR X
.ends

* Black-box entry subcircuit for sky130_fd_sc_hd__nor2_1 abstract view
.subckt sky130_fd_sc_hd__nor2_1 A B VGND VNB VPB VPWR Y
.ends

* Black-box entry subcircuit for sky130_fd_sc_hd__decap_8 abstract view
.subckt sky130_fd_sc_hd__decap_8 VGND VNB VPB VPWR
.ends

* Black-box entry subcircuit for sky130_fd_sc_hd__a22o_1 abstract view
.subckt sky130_fd_sc_hd__a22o_1 A1 A2 B1 B2 VGND VNB VPB VPWR X
.ends

* Black-box entry subcircuit for sky130_fd_sc_hd__a21oi_1 abstract view
.subckt sky130_fd_sc_hd__a21oi_1 A1 A2 B1 VGND VNB VPB VPWR Y
.ends

* Black-box entry subcircuit for sky130_fd_sc_hd__o21a_1 abstract view
.subckt sky130_fd_sc_hd__o21a_1 A1 A2 B1 VGND VNB VPB VPWR X
.ends

* Black-box entry subcircuit for sky130_fd_sc_hd__o21ba_1 abstract view
.subckt sky130_fd_sc_hd__o21ba_1 A1 A2 B1_N VGND VNB VPB VPWR X
.ends

* Black-box entry subcircuit for sky130_fd_sc_hd__a22oi_1 abstract view
.subckt sky130_fd_sc_hd__a22oi_1 A1 A2 B1 B2 VGND VNB VPB VPWR Y
.ends

* Black-box entry subcircuit for sky130_fd_sc_hd__a21o_1 abstract view
.subckt sky130_fd_sc_hd__a21o_1 A1 A2 B1 VGND VNB VPB VPWR X
.ends

* Black-box entry subcircuit for sky130_fd_sc_hd__a21bo_1 abstract view
.subckt sky130_fd_sc_hd__a21bo_1 A1 A2 B1_N VGND VNB VPB VPWR X
.ends

* Black-box entry subcircuit for sky130_fd_sc_hd__clkbuf_4 abstract view
.subckt sky130_fd_sc_hd__clkbuf_4 A VGND VNB VPB VPWR X
.ends

* Black-box entry subcircuit for sky130_fd_sc_hd__buf_4 abstract view
.subckt sky130_fd_sc_hd__buf_4 A VGND VNB VPB VPWR X
.ends

* Black-box entry subcircuit for sky130_fd_sc_hd__a32o_1 abstract view
.subckt sky130_fd_sc_hd__a32o_1 A1 A2 A3 B1 B2 VGND VNB VPB VPWR X
.ends

* Black-box entry subcircuit for sky130_fd_sc_hd__nand3_1 abstract view
.subckt sky130_fd_sc_hd__nand3_1 A B C VGND VNB VPB VPWR Y
.ends

* Black-box entry subcircuit for sky130_fd_sc_hd__a21oi_2 abstract view
.subckt sky130_fd_sc_hd__a21oi_2 A1 A2 B1 VGND VNB VPB VPWR Y
.ends

* Black-box entry subcircuit for sky130_fd_sc_hd__mux2_1 abstract view
.subckt sky130_fd_sc_hd__mux2_1 A0 A1 S VGND VNB VPB VPWR X
.ends

* Black-box entry subcircuit for sky130_fd_sc_hd__xor2_1 abstract view
.subckt sky130_fd_sc_hd__xor2_1 A B VGND VNB VPB VPWR X
.ends

* Black-box entry subcircuit for sky130_fd_sc_hd__and2_1 abstract view
.subckt sky130_fd_sc_hd__and2_1 A B VGND VNB VPB VPWR X
.ends

* Black-box entry subcircuit for sky130_fd_sc_hd__o21ai_1 abstract view
.subckt sky130_fd_sc_hd__o21ai_1 A1 A2 B1 VGND VNB VPB VPWR Y
.ends

* Black-box entry subcircuit for sky130_fd_sc_hd__o211ai_4 abstract view
.subckt sky130_fd_sc_hd__o211ai_4 A1 A2 B1 C1 VGND VNB VPB VPWR Y
.ends

* Black-box entry subcircuit for sky130_fd_sc_hd__or3_1 abstract view
.subckt sky130_fd_sc_hd__or3_1 A B C VGND VNB VPB VPWR X
.ends

* Black-box entry subcircuit for sky130_fd_sc_hd__nand2_2 abstract view
.subckt sky130_fd_sc_hd__nand2_2 A B VGND VNB VPB VPWR Y
.ends

* Black-box entry subcircuit for sky130_fd_sc_hd__mux4_1 abstract view
.subckt sky130_fd_sc_hd__mux4_1 A0 A1 A2 A3 S0 S1 VGND VNB VPB VPWR X
.ends

* Black-box entry subcircuit for sky130_fd_sc_hd__nor3_1 abstract view
.subckt sky130_fd_sc_hd__nor3_1 A B C VGND VNB VPB VPWR Y
.ends

* Black-box entry subcircuit for sky130_fd_sc_hd__o22a_1 abstract view
.subckt sky130_fd_sc_hd__o22a_1 A1 A2 B1 B2 VGND VNB VPB VPWR X
.ends

* Black-box entry subcircuit for sky130_fd_sc_hd__o311a_1 abstract view
.subckt sky130_fd_sc_hd__o311a_1 A1 A2 A3 B1 C1 VGND VNB VPB VPWR X
.ends

* Black-box entry subcircuit for sky130_fd_sc_hd__nand4_1 abstract view
.subckt sky130_fd_sc_hd__nand4_1 A B C D VGND VNB VPB VPWR Y
.ends

* Black-box entry subcircuit for sky130_fd_sc_hd__diode_2 abstract view
.subckt sky130_fd_sc_hd__diode_2 DIODE VGND VNB VPB VPWR
.ends

* Black-box entry subcircuit for sky130_fd_sc_hd__and3_1 abstract view
.subckt sky130_fd_sc_hd__and3_1 A B C VGND VNB VPB VPWR X
.ends

* Black-box entry subcircuit for sky130_fd_sc_hd__o211ai_2 abstract view
.subckt sky130_fd_sc_hd__o211ai_2 A1 A2 B1 C1 VGND VNB VPB VPWR Y
.ends

* Black-box entry subcircuit for sky130_fd_sc_hd__xor2_2 abstract view
.subckt sky130_fd_sc_hd__xor2_2 A B VGND VNB VPB VPWR X
.ends

* Black-box entry subcircuit for sky130_fd_sc_hd__or3_2 abstract view
.subckt sky130_fd_sc_hd__or3_2 A B C VGND VNB VPB VPWR X
.ends

* Black-box entry subcircuit for sky130_fd_sc_hd__and4bb_1 abstract view
.subckt sky130_fd_sc_hd__and4bb_1 A_N B_N C D VGND VNB VPB VPWR X
.ends

* Black-box entry subcircuit for sky130_fd_sc_hd__or3b_1 abstract view
.subckt sky130_fd_sc_hd__or3b_1 A B C_N VGND VNB VPB VPWR X
.ends

* Black-box entry subcircuit for sky130_fd_sc_hd__a211oi_1 abstract view
.subckt sky130_fd_sc_hd__a211oi_1 A1 A2 B1 C1 VGND VNB VPB VPWR Y
.ends

* Black-box entry subcircuit for sky130_fd_sc_hd__and2b_1 abstract view
.subckt sky130_fd_sc_hd__and2b_1 A_N B VGND VNB VPB VPWR X
.ends

* Black-box entry subcircuit for sky130_fd_sc_hd__o211a_1 abstract view
.subckt sky130_fd_sc_hd__o211a_1 A1 A2 B1 C1 VGND VNB VPB VPWR X
.ends

* Black-box entry subcircuit for sky130_fd_sc_hd__o221a_1 abstract view
.subckt sky130_fd_sc_hd__o221a_1 A1 A2 B1 B2 C1 VGND VNB VPB VPWR X
.ends

* Black-box entry subcircuit for sky130_fd_sc_hd__nand2b_1 abstract view
.subckt sky130_fd_sc_hd__nand2b_1 A_N B VGND VNB VPB VPWR Y
.ends

* Black-box entry subcircuit for sky130_fd_sc_hd__buf_2 abstract view
.subckt sky130_fd_sc_hd__buf_2 A VGND VNB VPB VPWR X
.ends

* Black-box entry subcircuit for sky130_fd_sc_hd__o2bb2a_1 abstract view
.subckt sky130_fd_sc_hd__o2bb2a_1 A1_N A2_N B1 B2 VGND VNB VPB VPWR X
.ends

* Black-box entry subcircuit for sky130_fd_sc_hd__nand4_2 abstract view
.subckt sky130_fd_sc_hd__nand4_2 A B C D VGND VNB VPB VPWR Y
.ends

* Black-box entry subcircuit for sky130_fd_sc_hd__inv_2 abstract view
.subckt sky130_fd_sc_hd__inv_2 A VGND VNB VPB VPWR Y
.ends

* Black-box entry subcircuit for sky130_fd_sc_hd__or4_1 abstract view
.subckt sky130_fd_sc_hd__or4_1 A B C D VGND VNB VPB VPWR X
.ends

* Black-box entry subcircuit for sky130_fd_sc_hd__and2_2 abstract view
.subckt sky130_fd_sc_hd__and2_2 A B VGND VNB VPB VPWR X
.ends

* Black-box entry subcircuit for sky130_fd_sc_hd__or2_2 abstract view
.subckt sky130_fd_sc_hd__or2_2 A B VGND VNB VPB VPWR X
.ends

* Black-box entry subcircuit for sky130_fd_sc_hd__a211o_1 abstract view
.subckt sky130_fd_sc_hd__a211o_1 A1 A2 B1 C1 VGND VNB VPB VPWR X
.ends

* Black-box entry subcircuit for sky130_fd_sc_hd__o211ai_1 abstract view
.subckt sky130_fd_sc_hd__o211ai_1 A1 A2 B1 C1 VGND VNB VPB VPWR Y
.ends

* Black-box entry subcircuit for sky130_fd_sc_hd__nor3b_4 abstract view
.subckt sky130_fd_sc_hd__nor3b_4 A B C_N VGND VNB VPB VPWR Y
.ends

* Black-box entry subcircuit for sky130_fd_sc_hd__a221o_1 abstract view
.subckt sky130_fd_sc_hd__a221o_1 A1 A2 B1 B2 C1 VGND VNB VPB VPWR X
.ends

* Black-box entry subcircuit for sky130_fd_sc_hd__clkbuf_2 abstract view
.subckt sky130_fd_sc_hd__clkbuf_2 A VGND VNB VPB VPWR X
.ends

* Black-box entry subcircuit for sky130_fd_sc_hd__a22oi_2 abstract view
.subckt sky130_fd_sc_hd__a22oi_2 A1 A2 B1 B2 VGND VNB VPB VPWR Y
.ends

* Black-box entry subcircuit for sky130_fd_sc_hd__a2bb2o_1 abstract view
.subckt sky130_fd_sc_hd__a2bb2o_1 A1_N A2_N B1 B2 VGND VNB VPB VPWR X
.ends

* Black-box entry subcircuit for sky130_fd_sc_hd__nor4_1 abstract view
.subckt sky130_fd_sc_hd__nor4_1 A B C D VGND VNB VPB VPWR Y
.ends

* Black-box entry subcircuit for sky130_fd_sc_hd__buf_1 abstract view
.subckt sky130_fd_sc_hd__buf_1 A VGND VNB VPB VPWR X
.ends

* Black-box entry subcircuit for sky130_fd_sc_hd__o21bai_1 abstract view
.subckt sky130_fd_sc_hd__o21bai_1 A1 A2 B1_N VGND VNB VPB VPWR Y
.ends

* Black-box entry subcircuit for sky130_fd_sc_hd__o32a_1 abstract view
.subckt sky130_fd_sc_hd__o32a_1 A1 A2 A3 B1 B2 VGND VNB VPB VPWR X
.ends

* Black-box entry subcircuit for sky130_fd_sc_hd__a211o_2 abstract view
.subckt sky130_fd_sc_hd__a211o_2 A1 A2 B1 C1 VGND VNB VPB VPWR X
.ends

* Black-box entry subcircuit for sky130_fd_sc_hd__a211oi_2 abstract view
.subckt sky130_fd_sc_hd__a211oi_2 A1 A2 B1 C1 VGND VNB VPB VPWR Y
.ends

* Black-box entry subcircuit for sky130_fd_sc_hd__o31a_1 abstract view
.subckt sky130_fd_sc_hd__o31a_1 A1 A2 A3 B1 VGND VNB VPB VPWR X
.ends

* Black-box entry subcircuit for sky130_fd_sc_hd__nor2_2 abstract view
.subckt sky130_fd_sc_hd__nor2_2 A B VGND VNB VPB VPWR Y
.ends

* Black-box entry subcircuit for sky130_fd_sc_hd__a311o_1 abstract view
.subckt sky130_fd_sc_hd__a311o_1 A1 A2 A3 B1 C1 VGND VNB VPB VPWR X
.ends

* Black-box entry subcircuit for sky130_fd_sc_hd__or4bb_2 abstract view
.subckt sky130_fd_sc_hd__or4bb_2 A B C_N D_N VGND VNB VPB VPWR X
.ends

* Black-box entry subcircuit for sky130_fd_sc_hd__or3_4 abstract view
.subckt sky130_fd_sc_hd__or3_4 A B C VGND VNB VPB VPWR X
.ends

* Black-box entry subcircuit for sky130_fd_sc_hd__dfxtp_1 abstract view
.subckt sky130_fd_sc_hd__dfxtp_1 CLK D VGND VNB VPB VPWR Q
.ends

* Black-box entry subcircuit for sky130_fd_sc_hd__a221oi_1 abstract view
.subckt sky130_fd_sc_hd__a221oi_1 A1 A2 B1 B2 C1 VGND VNB VPB VPWR Y
.ends

* Black-box entry subcircuit for sky130_fd_sc_hd__nor3_2 abstract view
.subckt sky130_fd_sc_hd__nor3_2 A B C VGND VNB VPB VPWR Y
.ends

* Black-box entry subcircuit for sky130_fd_sc_hd__xnor2_4 abstract view
.subckt sky130_fd_sc_hd__xnor2_4 A B VGND VNB VPB VPWR Y
.ends

* Black-box entry subcircuit for sky130_fd_sc_hd__a211oi_4 abstract view
.subckt sky130_fd_sc_hd__a211oi_4 A1 A2 B1 C1 VGND VNB VPB VPWR Y
.ends

* Black-box entry subcircuit for sky130_fd_sc_hd__or4b_2 abstract view
.subckt sky130_fd_sc_hd__or4b_2 A B C D_N VGND VNB VPB VPWR X
.ends

* Black-box entry subcircuit for sky130_fd_sc_hd__o21ai_2 abstract view
.subckt sky130_fd_sc_hd__o21ai_2 A1 A2 B1 VGND VNB VPB VPWR Y
.ends

* Black-box entry subcircuit for sky130_fd_sc_hd__nand3b_1 abstract view
.subckt sky130_fd_sc_hd__nand3b_1 A_N B C VGND VNB VPB VPWR Y
.ends

* Black-box entry subcircuit for sky130_fd_sc_hd__and3_2 abstract view
.subckt sky130_fd_sc_hd__and3_2 A B C VGND VNB VPB VPWR X
.ends

* Black-box entry subcircuit for sky130_fd_sc_hd__dlymetal6s2s_1 abstract view
.subckt sky130_fd_sc_hd__dlymetal6s2s_1 A VGND VNB VPB VPWR X
.ends

* Black-box entry subcircuit for sky130_fd_sc_hd__and3b_1 abstract view
.subckt sky130_fd_sc_hd__and3b_1 A_N B C VGND VNB VPB VPWR X
.ends

* Black-box entry subcircuit for sky130_fd_sc_hd__nor2_4 abstract view
.subckt sky130_fd_sc_hd__nor2_4 A B VGND VNB VPB VPWR Y
.ends

* Black-box entry subcircuit for sky130_fd_sc_hd__xnor2_2 abstract view
.subckt sky130_fd_sc_hd__xnor2_2 A B VGND VNB VPB VPWR Y
.ends

* Black-box entry subcircuit for sky130_fd_sc_hd__nor3_4 abstract view
.subckt sky130_fd_sc_hd__nor3_4 A B C VGND VNB VPB VPWR Y
.ends

* Black-box entry subcircuit for sky130_fd_sc_hd__clkbuf_8 abstract view
.subckt sky130_fd_sc_hd__clkbuf_8 A VGND VNB VPB VPWR X
.ends

* Black-box entry subcircuit for sky130_fd_sc_hd__clkbuf_1 abstract view
.subckt sky130_fd_sc_hd__clkbuf_1 A VGND VNB VPB VPWR X
.ends

* Black-box entry subcircuit for sky130_fd_sc_hd__o22ai_2 abstract view
.subckt sky130_fd_sc_hd__o22ai_2 A1 A2 B1 B2 VGND VNB VPB VPWR Y
.ends

* Black-box entry subcircuit for sky130_fd_sc_hd__nand3b_2 abstract view
.subckt sky130_fd_sc_hd__nand3b_2 A_N B C VGND VNB VPB VPWR Y
.ends

* Black-box entry subcircuit for sky130_fd_sc_hd__or4_4 abstract view
.subckt sky130_fd_sc_hd__or4_4 A B C D VGND VNB VPB VPWR X
.ends

* Black-box entry subcircuit for sky130_fd_sc_hd__a2bb2oi_1 abstract view
.subckt sky130_fd_sc_hd__a2bb2oi_1 A1_N A2_N B1 B2 VGND VNB VPB VPWR Y
.ends

* Black-box entry subcircuit for sky130_fd_sc_hd__and4b_1 abstract view
.subckt sky130_fd_sc_hd__and4b_1 A_N B C D VGND VNB VPB VPWR X
.ends

* Black-box entry subcircuit for sky130_fd_sc_hd__or4bb_1 abstract view
.subckt sky130_fd_sc_hd__or4bb_1 A B C_N D_N VGND VNB VPB VPWR X
.ends

* Black-box entry subcircuit for sky130_fd_sc_hd__a2111oi_1 abstract view
.subckt sky130_fd_sc_hd__a2111oi_1 A1 A2 B1 C1 D1 VGND VNB VPB VPWR Y
.ends

* Black-box entry subcircuit for sky130_fd_sc_hd__o211a_2 abstract view
.subckt sky130_fd_sc_hd__o211a_2 A1 A2 B1 C1 VGND VNB VPB VPWR X
.ends

* Black-box entry subcircuit for sky130_fd_sc_hd__a21boi_1 abstract view
.subckt sky130_fd_sc_hd__a21boi_1 A1 A2 B1_N VGND VNB VPB VPWR Y
.ends

* Black-box entry subcircuit for sky130_fd_sc_hd__and4bb_2 abstract view
.subckt sky130_fd_sc_hd__and4bb_2 A_N B_N C D VGND VNB VPB VPWR X
.ends

* Black-box entry subcircuit for sky130_fd_sc_hd__nor3b_2 abstract view
.subckt sky130_fd_sc_hd__nor3b_2 A B C_N VGND VNB VPB VPWR Y
.ends

* Black-box entry subcircuit for sky130_fd_sc_hd__nor3b_1 abstract view
.subckt sky130_fd_sc_hd__nor3b_1 A B C_N VGND VNB VPB VPWR Y
.ends

* Black-box entry subcircuit for sky130_fd_sc_hd__o31ai_1 abstract view
.subckt sky130_fd_sc_hd__o31ai_1 A1 A2 A3 B1 VGND VNB VPB VPWR Y
.ends

* Black-box entry subcircuit for sky130_fd_sc_hd__a2111o_1 abstract view
.subckt sky130_fd_sc_hd__a2111o_1 A1 A2 B1 C1 D1 VGND VNB VPB VPWR X
.ends

* Black-box entry subcircuit for sky130_fd_sc_hd__or4b_1 abstract view
.subckt sky130_fd_sc_hd__or4b_1 A B C D_N VGND VNB VPB VPWR X
.ends

* Black-box entry subcircuit for sky130_fd_sc_hd__o221ai_1 abstract view
.subckt sky130_fd_sc_hd__o221ai_1 A1 A2 B1 B2 C1 VGND VNB VPB VPWR Y
.ends

* Black-box entry subcircuit for sky130_fd_sc_hd__or3b_2 abstract view
.subckt sky130_fd_sc_hd__or3b_2 A B C_N VGND VNB VPB VPWR X
.ends

* Black-box entry subcircuit for sky130_fd_sc_hd__o31ai_2 abstract view
.subckt sky130_fd_sc_hd__o31ai_2 A1 A2 A3 B1 VGND VNB VPB VPWR Y
.ends

* Black-box entry subcircuit for sky130_fd_sc_hd__nand4_4 abstract view
.subckt sky130_fd_sc_hd__nand4_4 A B C D VGND VNB VPB VPWR Y
.ends

* Black-box entry subcircuit for sky130_fd_sc_hd__and3b_4 abstract view
.subckt sky130_fd_sc_hd__and3b_4 A_N B C VGND VNB VPB VPWR X
.ends

* Black-box entry subcircuit for sky130_fd_sc_hd__a31oi_1 abstract view
.subckt sky130_fd_sc_hd__a31oi_1 A1 A2 A3 B1 VGND VNB VPB VPWR Y
.ends

* Black-box entry subcircuit for sky130_fd_sc_hd__or2_4 abstract view
.subckt sky130_fd_sc_hd__or2_4 A B VGND VNB VPB VPWR X
.ends

.subckt alu VGND VPWR a[0] a[10] a[11] a[12] a[13] a[14] a[15] a[16] a[17] a[18] a[19]
+ a[1] a[20] a[21] a[22] a[23] a[24] a[25] a[26] a[27] a[28] a[29] a[2] a[30] a[31]
+ a[3] a[4] a[5] a[6] a[7] a[8] a[9] b[0] b[10] b[11] b[12] b[13] b[14] b[15] b[16]
+ b[17] b[18] b[19] b[1] b[20] b[21] b[22] b[23] b[24] b[25] b[26] b[27] b[28] b[29]
+ b[2] b[30] b[31] b[3] b[4] b[5] b[6] b[7] b[8] b[9] clock done_port opcode[0] opcode[1]
+ opcode[2] opcode[3] opcode[4] opcode[5] opcode[6] opcode[7] reset return_port[0]
+ return_port[10] return_port[11] return_port[12] return_port[13] return_port[14]
+ return_port[15] return_port[16] return_port[17] return_port[18] return_port[19]
+ return_port[1] return_port[20] return_port[21] return_port[22] return_port[23] return_port[24]
+ return_port[25] return_port[26] return_port[27] return_port[28] return_port[29]
+ return_port[2] return_port[30] return_port[31] return_port[3] return_port[4] return_port[5]
+ return_port[6] return_port[7] return_port[8] return_port[9] start_port
XFILLER_82_512 VPWR VGND VPWR VGND sky130_ef_sc_hd__decap_12
XFILLER_94_372 VGND VGND VPWR VPWR sky130_fd_sc_hd__fill_1
XFILLER_82_545 VPWR VGND VPWR VGND sky130_ef_sc_hd__decap_12
XFILLER_39_299 VPWR VGND VPWR VGND sky130_ef_sc_hd__decap_12
XFILLER_82_589 VPWR VGND VPWR VGND sky130_ef_sc_hd__decap_12
XTAP_TAPCELL_ROW_81_1226 VGND VPWR sky130_fd_sc_hd__tapvpwrvgnd_1
XFILLER_22_133 VGND VGND VPWR VPWR sky130_fd_sc_hd__decap_6
X_6845_ _2766_ _2767_ _2768_ _2769_ VGND VGND VPWR VPWR _2770_ sky130_fd_sc_hd__and4_1
XFILLER_52_29 VGND VGND VPWR VPWR sky130_fd_sc_hd__decap_4
XTAP_TAPCELL_ROW_61_982 VGND VPWR sky130_fd_sc_hd__tapvpwrvgnd_1
X_3988_ net231 _3176_ VGND VGND VPWR VPWR _3177_ sky130_fd_sc_hd__or2_1
XFILLER_10_306 VGND VGND VPWR VPWR sky130_fd_sc_hd__fill_2
X_6776_ _2685_ _2693_ VGND VGND VPWR VPWR _2694_ sky130_fd_sc_hd__xnor2_1
XTAP_TAPCELL_ROW_33_651 VGND VPWR sky130_fd_sc_hd__tapvpwrvgnd_1
X_5727_ _1545_ _1548_ _1549_ VGND VGND VPWR VPWR _1551_ sky130_fd_sc_hd__nand3_2
XFILLER_50_497 VPWR VGND VPWR VGND sky130_ef_sc_hd__decap_12
XPHY_EDGE_ROW_107_Left_224 VGND VGND VPWR VPWR sky130_fd_sc_hd__decap_3
X_5658_ net389 net302 VGND VGND VPWR VPWR _1475_ sky130_fd_sc_hd__nand2_1
X_4609_ net424 net196 _0292_ _0291_ VGND VGND VPWR VPWR _0372_ sky130_fd_sc_hd__a31o_1
XTAP_TAPCELL_ROW_79_1199 VGND VPWR sky130_fd_sc_hd__tapvpwrvgnd_1
X_5589_ _1398_ _1399_ VGND VGND VPWR VPWR _1400_ sky130_fd_sc_hd__nor2_1
XFILLER_104_433 VGND VGND VPWR VPWR sky130_fd_sc_hd__decap_8
XTAP_TAPCELL_ROW_92_1355 VGND VPWR sky130_fd_sc_hd__tapvpwrvgnd_1
XFILLER_77_15 VPWR VGND VPWR VGND sky130_ef_sc_hd__decap_12
XFILLER_104_477 VGND VGND VPWR VPWR sky130_fd_sc_hd__decap_8
XTAP_TAPCELL_ROW_5_310 VGND VPWR sky130_fd_sc_hd__tapvpwrvgnd_1
XFILLER_92_309 VGND VGND VPWR VPWR sky130_fd_sc_hd__decap_3
XPHY_EDGE_ROW_116_Left_233 VGND VGND VPWR VPWR sky130_fd_sc_hd__decap_3
XFILLER_73_534 VGND VGND VPWR VPWR sky130_fd_sc_hd__decap_4
XFILLER_45_225 VGND VGND VPWR VPWR sky130_fd_sc_hd__decap_8
XFILLER_93_69 VPWR VGND VPWR VGND sky130_ef_sc_hd__decap_12
XFILLER_26_41 VPWR VGND VPWR VGND sky130_ef_sc_hd__decap_12
XFILLER_14_601 VPWR VGND VPWR VGND sky130_ef_sc_hd__decap_12
XFILLER_14_645 VPWR VGND VPWR VGND sky130_ef_sc_hd__decap_12
XFILLER_26_85 VPWR VGND VPWR VGND sky130_ef_sc_hd__decap_12
XFILLER_41_420 VPWR VGND VPWR VGND sky130_ef_sc_hd__decap_12
XFILLER_41_442 VGND VGND VPWR VPWR sky130_fd_sc_hd__fill_1
XFILLER_14_689 VGND VGND VPWR VPWR sky130_fd_sc_hd__decap_3
XTAP_TAPCELL_ROW_101_1462 VGND VPWR sky130_fd_sc_hd__tapvpwrvgnd_1
XFILLER_41_497 VGND VGND VPWR VPWR sky130_fd_sc_hd__decap_6
XFILLER_42_62 VGND VGND VPWR VPWR sky130_fd_sc_hd__decap_4
XFILLER_9_159 VGND VGND VPWR VPWR sky130_fd_sc_hd__decap_8
XTAP_TAPCELL_ROW_11_389 VGND VPWR sky130_fd_sc_hd__tapvpwrvgnd_1
XTAP_TAPCELL_ROW_11_378 VGND VPWR sky130_fd_sc_hd__tapvpwrvgnd_1
XFILLER_5_321 VGND VGND VPWR VPWR sky130_fd_sc_hd__decap_3
XFILLER_96_637 VGND VGND VPWR VPWR sky130_fd_sc_hd__decap_6
XTAP_TAPCELL_ROW_112_1591 VGND VPWR sky130_fd_sc_hd__tapvpwrvgnd_1
XFILLER_68_339 VPWR VGND VPWR VGND sky130_ef_sc_hd__decap_12
XFILLER_3_89 VGND VGND VPWR VPWR sky130_fd_sc_hd__fill_1
XFILLER_95_169 VGND VGND VPWR VPWR sky130_fd_sc_hd__decap_3
XFILLER_95_158 VGND VGND VPWR VPWR sky130_fd_sc_hd__decap_8
XFILLER_67_92 VPWR VGND VPWR VGND sky130_ef_sc_hd__decap_12
XFILLER_64_501 VGND VGND VPWR VPWR sky130_fd_sc_hd__decap_4
XFILLER_49_597 VGND VGND VPWR VPWR sky130_fd_sc_hd__decap_6
XFILLER_91_331 VGND VGND VPWR VPWR sky130_fd_sc_hd__decap_4
X_4960_ net410 net334 net328 net418 VGND VGND VPWR VPWR _0718_ sky130_fd_sc_hd__a22o_1
XFILLER_83_80 VPWR VGND VPWR VGND sky130_ef_sc_hd__decap_12
XFILLER_64_589 VPWR VGND VPWR VGND sky130_ef_sc_hd__decap_12
XTAP_TAPCELL_ROW_19_478 VGND VPWR sky130_fd_sc_hd__tapvpwrvgnd_1
XFILLER_51_228 VGND VGND VPWR VPWR sky130_fd_sc_hd__decap_8
X_4891_ net227 net387 net313 net240 VGND VGND VPWR VPWR _0650_ sky130_fd_sc_hd__a22o_1
X_3911_ net138 _3094_ _3102_ VGND VGND VPWR VPWR _3103_ sky130_fd_sc_hd__a21oi_1
X_3842_ _3027_ _3029_ net127 VGND VGND VPWR VPWR _3037_ sky130_fd_sc_hd__o21a_1
X_6630_ _2533_ _2534_ VGND VGND VPWR VPWR _2535_ sky130_fd_sc_hd__nor2_1
XFILLER_20_637 VGND VGND VPWR VPWR sky130_fd_sc_hd__decap_6
X_6561_ _2450_ _2459_ VGND VGND VPWR VPWR _2461_ sky130_fd_sc_hd__xnor2_1
XTAP_TAPCELL_ROW_30_610 VGND VPWR sky130_fd_sc_hd__tapvpwrvgnd_1
X_3773_ _2965_ _2969_ _2970_ VGND VGND VPWR VPWR _2971_ sky130_fd_sc_hd__o21ba_1
X_5512_ _1191_ _1314_ _1315_ VGND VGND VPWR VPWR _1316_ sky130_fd_sc_hd__nand3_2
XFILLER_9_671 VGND VGND VPWR VPWR sky130_fd_sc_hd__fill_1
X_6492_ net448 net185 net340 net460 VGND VGND VPWR VPWR _2385_ sky130_fd_sc_hd__a22oi_1
X_5443_ _1237_ _1238_ _1234_ VGND VGND VPWR VPWR _1240_ sky130_fd_sc_hd__a21o_1
X_5374_ _1049_ _1051_ _1050_ VGND VGND VPWR VPWR _1165_ sky130_fd_sc_hd__a21bo_1
X_4325_ net249 net414 VGND VGND VPWR VPWR _0094_ sky130_fd_sc_hd__nand2_1
XFILLER_99_431 VGND VGND VPWR VPWR sky130_fd_sc_hd__fill_1
XFILLER_101_414 VGND VGND VPWR VPWR sky130_fd_sc_hd__fill_2
XFILLER_87_615 VGND VGND VPWR VPWR sky130_fd_sc_hd__fill_1
Xfanout127 _1876_ VGND VGND VPWR VPWR net127 sky130_fd_sc_hd__clkbuf_4
Xfanout138 _1059_ VGND VGND VPWR VPWR net138 sky130_fd_sc_hd__clkbuf_4
XFILLER_59_317 VPWR VGND VPWR VGND sky130_ef_sc_hd__decap_12
XFILLER_59_306 VGND VGND VPWR VPWR sky130_fd_sc_hd__decap_3
XFILLER_101_447 VGND VGND VPWR VPWR sky130_fd_sc_hd__fill_1
Xfanout149 _0045_ VGND VGND VPWR VPWR net149 sky130_fd_sc_hd__buf_4
X_4256_ _0029_ _0030_ VGND VGND VPWR VPWR _0031_ sky130_fd_sc_hd__or2_1
XFILLER_74_309 VPWR VGND VPWR VGND sky130_ef_sc_hd__decap_12
X_4187_ _3021_ _3134_ VGND VGND VPWR VPWR _3367_ sky130_fd_sc_hd__nand2_1
XTAP_TAPCELL_ROW_38_710 VGND VPWR sky130_fd_sc_hd__tapvpwrvgnd_1
XFILLER_103_57 VPWR VGND VPWR VGND sky130_ef_sc_hd__decap_12
XFILLER_55_545 VGND VGND VPWR VPWR sky130_fd_sc_hd__fill_1
XFILLER_27_236 VPWR VGND VPWR VGND sky130_ef_sc_hd__decap_12
XFILLER_23_420 VGND VGND VPWR VPWR sky130_fd_sc_hd__fill_2
XFILLER_35_291 VPWR VGND VPWR VGND sky130_ef_sc_hd__decap_12
XFILLER_11_615 VGND VGND VPWR VPWR sky130_fd_sc_hd__fill_1
X_6828_ net258 net301 _2527_ _2528_ net297 VGND VGND VPWR VPWR _2752_ sky130_fd_sc_hd__a32o_1
X_6759_ net222 net428 net427 net234 VGND VGND VPWR VPWR _2676_ sky130_fd_sc_hd__a22o_1
XFILLER_6_129 VGND VGND VPWR VPWR sky130_fd_sc_hd__decap_8
XFILLER_104_230 VGND VGND VPWR VPWR sky130_fd_sc_hd__decap_4
XFILLER_2_324 VGND VGND VPWR VPWR sky130_fd_sc_hd__decap_8
XFILLER_2_346 VGND VGND VPWR VPWR sky130_fd_sc_hd__fill_1
XFILLER_2_357 VGND VGND VPWR VPWR sky130_fd_sc_hd__fill_1
XFILLER_104_274 VGND VGND VPWR VPWR sky130_fd_sc_hd__decap_4
XFILLER_78_637 VGND VGND VPWR VPWR sky130_fd_sc_hd__decap_6
XFILLER_77_125 VGND VGND VPWR VPWR sky130_fd_sc_hd__fill_1
XFILLER_93_629 VPWR VGND VPWR VGND sky130_ef_sc_hd__decap_12
XFILLER_92_117 VGND VGND VPWR VPWR sky130_fd_sc_hd__decap_3
XFILLER_86_681 VGND VGND VPWR VPWR sky130_fd_sc_hd__decap_8
XFILLER_18_225 VGND VGND VPWR VPWR sky130_fd_sc_hd__decap_3
XFILLER_37_51 VGND VGND VPWR VPWR sky130_fd_sc_hd__decap_4
XFILLER_46_523 VGND VGND VPWR VPWR sky130_fd_sc_hd__decap_8
XFILLER_46_545 VPWR VGND VPWR VGND sky130_ef_sc_hd__decap_12
XFILLER_46_567 VPWR VGND VPWR VGND sky130_ef_sc_hd__decap_12
XFILLER_46_589 VGND VGND VPWR VPWR sky130_fd_sc_hd__decap_3
XFILLER_61_559 VGND VGND VPWR VPWR sky130_fd_sc_hd__fill_1
XTAP_TAPCELL_ROW_16_448 VGND VPWR sky130_fd_sc_hd__tapvpwrvgnd_1
XFILLER_14_442 VGND VGND VPWR VPWR sky130_fd_sc_hd__fill_2
XFILLER_14_453 VGND VGND VPWR VPWR sky130_fd_sc_hd__fill_2
XFILLER_14_464 VGND VGND VPWR VPWR sky130_fd_sc_hd__decap_6
XTAP_TAPCELL_ROW_44_779 VGND VPWR sky130_fd_sc_hd__tapvpwrvgnd_1
XFILLER_53_61 VGND VGND VPWR VPWR sky130_fd_sc_hd__fill_1
XFILLER_41_261 VPWR VGND VPWR VGND sky130_ef_sc_hd__decap_12
XFILLER_10_681 VGND VGND VPWR VPWR sky130_fd_sc_hd__decap_8
XFILLER_115_517 VPWR VGND VPWR VGND sky130_ef_sc_hd__decap_12
XTAP_TAPCELL_ROW_114_1620 VGND VPWR sky130_fd_sc_hd__tapvpwrvgnd_1
X_5090_ _0850_ _0854_ _0855_ VGND VGND VPWR VPWR _0856_ sky130_fd_sc_hd__nand3_2
X_4110_ _3247_ _3269_ VGND VGND VPWR VPWR _3293_ sky130_fd_sc_hd__nor2_1
XFILLER_56_309 VGND VGND VPWR VPWR sky130_fd_sc_hd__decap_4
X_4041_ net445 net271 VGND VGND VPWR VPWR _3227_ sky130_fd_sc_hd__or2_1
XFILLER_49_361 VGND VGND VPWR VPWR sky130_fd_sc_hd__decap_4
XFILLER_37_556 VGND VGND VPWR VPWR sky130_fd_sc_hd__decap_4
XFILLER_37_567 VGND VGND VPWR VPWR sky130_fd_sc_hd__fill_1
XFILLER_52_504 VPWR VGND VPWR VGND sky130_ef_sc_hd__decap_12
X_5992_ _1818_ _1835_ _1836_ VGND VGND VPWR VPWR _1839_ sky130_fd_sc_hd__nand3_1
X_4943_ _0614_ _0695_ _0694_ VGND VGND VPWR VPWR _0701_ sky130_fd_sc_hd__a21oi_2
XTAP_TAPCELL_ROW_65_1029 VGND VPWR sky130_fd_sc_hd__tapvpwrvgnd_1
X_4874_ _0631_ _0632_ _0630_ VGND VGND VPWR VPWR _0633_ sky130_fd_sc_hd__a21o_1
XFILLER_60_570 VGND VGND VPWR VPWR sky130_fd_sc_hd__fill_2
X_6613_ _2514_ _2515_ VGND VGND VPWR VPWR _2516_ sky130_fd_sc_hd__xnor2_1
X_3825_ net153 _3019_ _3020_ VGND VGND VPWR VPWR _3021_ sky130_fd_sc_hd__a21o_1
XFILLER_20_445 VGND VGND VPWR VPWR sky130_fd_sc_hd__decap_8
X_3756_ _1397_ _1703_ net155 VGND VGND VPWR VPWR _2955_ sky130_fd_sc_hd__mux2_1
X_6544_ _2439_ _2440_ VGND VGND VPWR VPWR _2442_ sky130_fd_sc_hd__xor2_1
X_6475_ _2364_ _2365_ VGND VGND VPWR VPWR _2366_ sky130_fd_sc_hd__nor2_1
XTAP_TAPCELL_ROW_76_1158 VGND VPWR sky130_fd_sc_hd__tapvpwrvgnd_1
X_3687_ net232 _2888_ VGND VGND VPWR VPWR _2889_ sky130_fd_sc_hd__nor2_1
X_5426_ _1219_ _1220_ VGND VGND VPWR VPWR _1221_ sky130_fd_sc_hd__and2_1
XTAP_TAPCELL_ROW_76_1169 VGND VPWR sky130_fd_sc_hd__tapvpwrvgnd_1
XFILLER_99_261 VPWR VGND VPWR VGND sky130_ef_sc_hd__decap_12
XFILLER_87_401 VGND VGND VPWR VPWR sky130_fd_sc_hd__fill_2
X_5357_ net421 net300 net295 net459 VGND VGND VPWR VPWR _1147_ sky130_fd_sc_hd__a22o_1
X_4308_ _0075_ _0076_ _0057_ VGND VGND VPWR VPWR _0078_ sky130_fd_sc_hd__a21o_1
X_5288_ _0963_ _1069_ VGND VGND VPWR VPWR _1072_ sky130_fd_sc_hd__xnor2_1
XFILLER_101_233 VGND VGND VPWR VPWR sky130_fd_sc_hd__fill_2
XFILLER_75_629 VPWR VGND VPWR VGND sky130_ef_sc_hd__decap_12
XFILLER_59_169 VGND VGND VPWR VPWR sky130_fd_sc_hd__decap_8
XFILLER_59_158 VGND VGND VPWR VPWR sky130_fd_sc_hd__decap_3
X_4239_ _0906_ net54 _0014_ VGND VGND VPWR VPWR _0015_ sky130_fd_sc_hd__o21a_1
XFILLER_101_277 VGND VGND VPWR VPWR sky130_fd_sc_hd__decap_3
XFILLER_74_139 VGND VGND VPWR VPWR sky130_fd_sc_hd__fill_1
XFILLER_68_681 VGND VGND VPWR VPWR sky130_fd_sc_hd__decap_4
XFILLER_74_27 VGND VGND VPWR VPWR sky130_fd_sc_hd__fill_1
XFILLER_28_556 VPWR VGND VPWR VGND sky130_ef_sc_hd__decap_12
XFILLER_83_673 VPWR VGND VPWR VGND sky130_ef_sc_hd__decap_12
XFILLER_28_589 VPWR VGND VPWR VGND sky130_ef_sc_hd__decap_12
XTAP_TAPCELL_ROW_87_1298 VGND VPWR sky130_fd_sc_hd__tapvpwrvgnd_1
XFILLER_90_15 VPWR VGND VPWR VGND sky130_ef_sc_hd__decap_12
XFILLER_30_209 VGND VGND VPWR VPWR sky130_fd_sc_hd__decap_6
XFILLER_90_48 VGND VGND VPWR VPWR sky130_fd_sc_hd__fill_1
XFILLER_11_412 VPWR VGND VPWR VGND sky130_ef_sc_hd__decap_12
XTAP_TAPCELL_ROW_13_407 VGND VPWR sky130_fd_sc_hd__tapvpwrvgnd_1
XFILLER_23_272 VGND VGND VPWR VPWR sky130_fd_sc_hd__decap_8
XTAP_TAPCELL_ROW_41_738 VGND VPWR sky130_fd_sc_hd__tapvpwrvgnd_1
XTAP_TAPCELL_ROW_41_749 VGND VPWR sky130_fd_sc_hd__tapvpwrvgnd_1
XFILLER_11_478 VGND VGND VPWR VPWR sky130_fd_sc_hd__decap_8
XFILLER_109_377 VPWR VGND VPWR VGND sky130_ef_sc_hd__decap_12
XFILLER_105_561 VPWR VGND VPWR VGND sky130_ef_sc_hd__decap_12
XFILLER_93_404 VGND VGND VPWR VPWR sky130_fd_sc_hd__decap_4
XFILLER_38_309 VGND VGND VPWR VPWR sky130_fd_sc_hd__decap_4
XFILLER_48_50 VPWR VGND VPWR VGND sky130_ef_sc_hd__decap_12
XFILLER_78_489 VPWR VGND VPWR VGND sky130_ef_sc_hd__decap_12
XFILLER_48_83 VGND VGND VPWR VPWR sky130_fd_sc_hd__fill_1
XTAP_TAPCELL_ROW_49_838 VGND VPWR sky130_fd_sc_hd__tapvpwrvgnd_1
XFILLER_0_57 VGND VGND VPWR VPWR sky130_fd_sc_hd__decap_4
XFILLER_0_79 VGND VGND VPWR VPWR sky130_fd_sc_hd__decap_4
XTAP_TAPCELL_ROW_29_595 VGND VPWR sky130_fd_sc_hd__tapvpwrvgnd_1
XFILLER_9_55 VGND VGND VPWR VPWR sky130_fd_sc_hd__fill_1
X_4590_ _0310_ _0311_ _0322_ _0352_ VGND VGND VPWR VPWR _0353_ sky130_fd_sc_hd__a31o_1
XPHY_EDGE_ROW_104_Right_104 VGND VGND VPWR VPWR sky130_fd_sc_hd__decap_3
X_3610_ _2739_ _2799_ _2813_ VGND VGND VPWR VPWR _2814_ sky130_fd_sc_hd__o21ai_1
XFILLER_80_92 VPWR VGND VPWR VGND sky130_ef_sc_hd__decap_12
X_3541_ _2193_ _2237_ net244 VGND VGND VPWR VPWR _2248_ sky130_fd_sc_hd__mux2_1
XFILLER_115_303 VGND VGND VPWR VPWR sky130_fd_sc_hd__decap_3
XFILLER_6_460 VPWR VGND VPWR VGND sky130_ef_sc_hd__decap_12
X_3472_ net164 net24 _1484_ VGND VGND VPWR VPWR _1495_ sky130_fd_sc_hd__a21bo_1
XFILLER_6_493 VGND VGND VPWR VPWR sky130_fd_sc_hd__decap_6
X_6260_ net449 net446 net205 net198 VGND VGND VPWR VPWR _2132_ sky130_fd_sc_hd__and4_1
XFILLER_89_90 VPWR VGND VPWR VGND sky130_ef_sc_hd__decap_12
XFILLER_88_209 VGND VGND VPWR VPWR sky130_fd_sc_hd__fill_1
X_5211_ _0844_ _0846_ _0986_ _0987_ VGND VGND VPWR VPWR _0988_ sky130_fd_sc_hd__o211ai_4
X_6191_ _2045_ _2054_ _2055_ VGND VGND VPWR VPWR _2056_ sky130_fd_sc_hd__nand3_2
X_5142_ net313 net210 net202 net387 VGND VGND VPWR VPWR _0912_ sky130_fd_sc_hd__a22o_1
XFILLER_69_445 VGND VGND VPWR VPWR sky130_fd_sc_hd__decap_3
XFILLER_111_553 VGND VGND VPWR VPWR sky130_fd_sc_hd__decap_6
XFILLER_96_253 VPWR VGND VPWR VGND sky130_ef_sc_hd__decap_12
XFILLER_111_597 VPWR VGND VPWR VGND sky130_ef_sc_hd__decap_12
X_5073_ _0833_ _0834_ _0835_ VGND VGND VPWR VPWR _0837_ sky130_fd_sc_hd__nand3_1
XTAP_TAPCELL_ROW_71_1099 VGND VPWR sky130_fd_sc_hd__tapvpwrvgnd_1
X_4024_ _3162_ _3168_ _3185_ VGND VGND VPWR VPWR _3211_ sky130_fd_sc_hd__or3_1
XFILLER_65_673 VPWR VGND VPWR VGND sky130_ef_sc_hd__decap_12
XFILLER_52_301 VGND VGND VPWR VPWR sky130_fd_sc_hd__decap_6
XFILLER_64_194 VGND VGND VPWR VPWR sky130_fd_sc_hd__fill_2
XFILLER_12_209 VPWR VGND VPWR VGND sky130_ef_sc_hd__decap_12
X_5975_ net172 net192 _1616_ _1614_ VGND VGND VPWR VPWR _1821_ sky130_fd_sc_hd__a31o_1
XFILLER_52_378 VGND VGND VPWR VPWR sky130_fd_sc_hd__decap_3
X_4926_ _0681_ _0682_ _0645_ VGND VGND VPWR VPWR _0685_ sky130_fd_sc_hd__a21o_1
X_4857_ _0473_ _0616_ VGND VGND VPWR VPWR _0617_ sky130_fd_sc_hd__nor2_1
XFILLER_20_253 VGND VGND VPWR VPWR sky130_fd_sc_hd__decap_8
X_3808_ net383 net337 VGND VGND VPWR VPWR _3004_ sky130_fd_sc_hd__nand2_2
X_4788_ _0544_ _0547_ VGND VGND VPWR VPWR _0548_ sky130_fd_sc_hd__xnor2_1
X_6527_ _2252_ _2254_ _2422_ VGND VGND VPWR VPWR _2424_ sky130_fd_sc_hd__o21a_1
X_3739_ _2818_ _2828_ _2829_ _2832_ net153 net158 VGND VGND VPWR VPWR _2939_ sky130_fd_sc_hd__mux4_1
X_6458_ net390 net266 VGND VGND VPWR VPWR _2348_ sky130_fd_sc_hd__nand2_1
X_5409_ _1100_ _1202_ _1203_ VGND VGND VPWR VPWR _1204_ sky130_fd_sc_hd__nor3_1
X_6389_ _2269_ _2271_ VGND VGND VPWR VPWR _2273_ sky130_fd_sc_hd__xnor2_1
XFILLER_85_15 VGND VGND VPWR VPWR sky130_fd_sc_hd__decap_8
XFILLER_0_669 VGND VGND VPWR VPWR sky130_fd_sc_hd__decap_3
XTAP_TAPCELL_ROW_89_1316 VGND VPWR sky130_fd_sc_hd__tapvpwrvgnd_1
XFILLER_18_53 VPWR VGND VPWR VGND sky130_ef_sc_hd__decap_12
XFILLER_43_301 VGND VGND VPWR VPWR sky130_fd_sc_hd__fill_1
XTAP_TAPCELL_ROW_46_808 VGND VPWR sky130_fd_sc_hd__tapvpwrvgnd_1
XFILLER_18_97 VGND VGND VPWR VPWR sky130_fd_sc_hd__fill_1
XFILLER_43_312 VGND VGND VPWR VPWR sky130_fd_sc_hd__fill_2
XTAP_TAPCELL_ROW_54_896 VGND VPWR sky130_fd_sc_hd__tapvpwrvgnd_1
XTAP_TAPCELL_ROW_26_565 VGND VPWR sky130_fd_sc_hd__tapvpwrvgnd_1
XFILLER_34_41 VPWR VGND VPWR VGND sky130_ef_sc_hd__decap_12
XFILLER_70_197 VGND VGND VPWR VPWR sky130_fd_sc_hd__decap_6
XFILLER_11_242 VGND VGND VPWR VPWR sky130_fd_sc_hd__decap_4
XFILLER_11_297 VGND VGND VPWR VPWR sky130_fd_sc_hd__decap_8
XFILLER_112_306 VGND VGND VPWR VPWR sky130_fd_sc_hd__fill_2
XFILLER_3_496 VGND VGND VPWR VPWR sky130_fd_sc_hd__decap_8
XFILLER_105_391 VGND VGND VPWR VPWR sky130_fd_sc_hd__fill_1
XFILLER_78_253 VPWR VGND VPWR VGND sky130_ef_sc_hd__decap_12
XFILLER_93_201 VGND VGND VPWR VPWR sky130_fd_sc_hd__decap_3
XFILLER_66_426 VGND VGND VPWR VPWR sky130_fd_sc_hd__decap_4
XFILLER_38_117 VGND VGND VPWR VPWR sky130_fd_sc_hd__decap_8
XFILLER_39_629 VPWR VGND VPWR VGND sky130_ef_sc_hd__decap_12
XFILLER_93_223 VGND VGND VPWR VPWR sky130_fd_sc_hd__fill_1
XFILLER_66_448 VGND VGND VPWR VPWR sky130_fd_sc_hd__fill_2
XFILLER_38_139 VGND VGND VPWR VPWR sky130_fd_sc_hd__fill_1
XTAP_TAPCELL_ROW_109_1563 VGND VPWR sky130_fd_sc_hd__tapvpwrvgnd_1
XFILLER_93_289 VGND VGND VPWR VPWR sky130_fd_sc_hd__decap_3
XFILLER_93_267 VPWR VGND VPWR VGND sky130_ef_sc_hd__decap_12
XFILLER_47_651 VPWR VGND VPWR VGND sky130_ef_sc_hd__decap_12
XFILLER_47_673 VPWR VGND VPWR VGND sky130_ef_sc_hd__decap_12
XFILLER_74_470 VGND VGND VPWR VPWR sky130_fd_sc_hd__decap_6
XFILLER_34_301 VGND VGND VPWR VPWR sky130_fd_sc_hd__decap_6
XFILLER_22_507 VGND VGND VPWR VPWR sky130_fd_sc_hd__decap_4
XFILLER_98_3 VPWR VGND VPWR VGND sky130_ef_sc_hd__decap_12
X_5760_ _1537_ _1538_ _1541_ net165 VGND VGND VPWR VPWR _1586_ sky130_fd_sc_hd__o22a_1
XFILLER_22_529 VGND VGND VPWR VPWR sky130_fd_sc_hd__decap_3
XFILLER_34_389 VGND VGND VPWR VPWR sky130_fd_sc_hd__fill_2
X_4711_ _0341_ _0342_ _0402_ _0403_ _0406_ VGND VGND VPWR VPWR _0473_ sky130_fd_sc_hd__o311a_1
X_5691_ _1413_ _1421_ _1420_ VGND VGND VPWR VPWR _1511_ sky130_fd_sc_hd__a21bo_1
X_4642_ _0341_ _0342_ _0340_ VGND VGND VPWR VPWR _0405_ sky130_fd_sc_hd__o21a_1
XFILLER_30_551 VGND VGND VPWR VPWR sky130_fd_sc_hd__decap_8
X_4573_ _0289_ _0334_ _0335_ VGND VGND VPWR VPWR _0337_ sky130_fd_sc_hd__nand3_1
XFILLER_116_645 VPWR VGND VPWR VGND sky130_ef_sc_hd__decap_12
XFILLER_115_111 VGND VGND VPWR VPWR sky130_fd_sc_hd__fill_1
X_3524_ _2029_ _2051_ net284 VGND VGND VPWR VPWR _2062_ sky130_fd_sc_hd__mux2_1
X_6312_ _2186_ _2187_ VGND VGND VPWR VPWR _2188_ sky130_fd_sc_hd__nor2_1
XTAP_TAPCELL_ROW_73_1128 VGND VPWR sky130_fd_sc_hd__tapvpwrvgnd_1
X_3455_ net351 net462 VGND VGND VPWR VPWR _1310_ sky130_fd_sc_hd__nand2_1
X_6243_ net223 net16 net439 net235 VGND VGND VPWR VPWR _2113_ sky130_fd_sc_hd__a22oi_1
XFILLER_69_220 VGND VGND VPWR VPWR sky130_fd_sc_hd__decap_4
X_6174_ _1890_ _1892_ VGND VGND VPWR VPWR _2037_ sky130_fd_sc_hd__nand2_1
XFILLER_97_573 VPWR VGND VPWR VGND sky130_ef_sc_hd__decap_12
X_5125_ net236 net224 net221 net177 VGND VGND VPWR VPWR _0893_ sky130_fd_sc_hd__nand4_1
X_5056_ _0816_ _0817_ VGND VGND VPWR VPWR _0818_ sky130_fd_sc_hd__and2_1
X_4007_ net231 _3194_ VGND VGND VPWR VPWR _3195_ sky130_fd_sc_hd__or2_1
XFILLER_25_334 VGND VGND VPWR VPWR sky130_fd_sc_hd__fill_2
XTAP_TAPCELL_ROW_84_1257 VGND VPWR sky130_fd_sc_hd__tapvpwrvgnd_1
XFILLER_53_665 VGND VGND VPWR VPWR sky130_fd_sc_hd__decap_6
XFILLER_25_356 VGND VGND VPWR VPWR sky130_fd_sc_hd__fill_2
XFILLER_37_194 VPWR VGND VPWR VGND sky130_ef_sc_hd__decap_12
XFILLER_52_153 VGND VGND VPWR VPWR sky130_fd_sc_hd__decap_4
XFILLER_111_57 VPWR VGND VPWR VGND sky130_ef_sc_hd__decap_12
X_5958_ net224 net447 net443 net237 VGND VGND VPWR VPWR _1803_ sky130_fd_sc_hd__a22o_1
X_4909_ _0663_ _0666_ _0667_ VGND VGND VPWR VPWR _0668_ sky130_fd_sc_hd__nand3_2
XFILLER_71_39 VGND VGND VPWR VPWR sky130_fd_sc_hd__decap_6
XFILLER_21_540 VGND VGND VPWR VPWR sky130_fd_sc_hd__decap_8
XTAP_TAPCELL_ROW_23_524 VGND VPWR sky130_fd_sc_hd__tapvpwrvgnd_1
X_5889_ net468 net451 net264 net256 VGND VGND VPWR VPWR _1727_ sky130_fd_sc_hd__and4_1
XTAP_TAPCELL_ROW_51_866 VGND VPWR sky130_fd_sc_hd__tapvpwrvgnd_1
XTAP_TAPCELL_ROW_95_1397 VGND VPWR sky130_fd_sc_hd__tapvpwrvgnd_1
XTAP_TAPCELL_ROW_95_1386 VGND VPWR sky130_fd_sc_hd__tapvpwrvgnd_1
XFILLER_20_65 VGND VGND VPWR VPWR sky130_fd_sc_hd__decap_6
XFILLER_0_433 VGND VGND VPWR VPWR sky130_fd_sc_hd__decap_3
XFILLER_0_477 VPWR VGND VPWR VGND sky130_ef_sc_hd__decap_12
XTAP_TAPCELL_ROW_59_955 VGND VPWR sky130_fd_sc_hd__tapvpwrvgnd_1
XFILLER_29_673 VPWR VGND VPWR VGND sky130_ef_sc_hd__decap_12
XTAP_TAPCELL_ROW_3_293 VGND VPWR sky130_fd_sc_hd__tapvpwrvgnd_1
XTAP_TAPCELL_ROW_3_282 VGND VPWR sky130_fd_sc_hd__tapvpwrvgnd_1
XFILLER_16_301 VGND VGND VPWR VPWR sky130_fd_sc_hd__decap_6
XFILLER_44_643 VGND VGND VPWR VPWR sky130_fd_sc_hd__fill_1
XFILLER_45_84 VGND VGND VPWR VPWR sky130_fd_sc_hd__fill_1
XFILLER_8_533 VPWR VGND VPWR VGND sky130_ef_sc_hd__decap_12
XANTENNA_5 a[27] VGND VGND VPWR VPWR sky130_fd_sc_hd__diode_2
XFILLER_113_615 VGND VGND VPWR VPWR sky130_fd_sc_hd__fill_1
XFILLER_98_337 VGND VGND VPWR VPWR sky130_fd_sc_hd__decap_3
XFILLER_3_293 VPWR VGND VPWR VGND sky130_ef_sc_hd__decap_12
XFILLER_100_309 VPWR VGND VPWR VGND sky130_ef_sc_hd__decap_12
XFILLER_66_201 VPWR VGND VPWR VGND sky130_ef_sc_hd__decap_12
XFILLER_13_3 VPWR VGND VPWR VGND sky130_ef_sc_hd__decap_12
XFILLER_94_587 VGND VGND VPWR VPWR sky130_fd_sc_hd__fill_1
XFILLER_81_204 VPWR VGND VPWR VGND sky130_ef_sc_hd__decap_12
XFILLER_54_407 VGND VGND VPWR VPWR sky130_fd_sc_hd__fill_1
XFILLER_66_289 VPWR VGND VPWR VGND sky130_ef_sc_hd__decap_12
X_6861_ _2670_ _2787_ VGND VGND VPWR VPWR _2788_ sky130_fd_sc_hd__xnor2_1
XFILLER_35_665 VGND VGND VPWR VPWR sky130_fd_sc_hd__decap_6
X_5812_ _1640_ _1641_ _1642_ VGND VGND VPWR VPWR _1643_ sky130_fd_sc_hd__and3_1
X_6792_ net430 net276 _2535_ _2534_ VGND VGND VPWR VPWR _2712_ sky130_fd_sc_hd__a31o_1
XFILLER_50_613 VPWR VGND VPWR VGND sky130_ef_sc_hd__decap_12
XFILLER_34_197 VGND VGND VPWR VPWR sky130_fd_sc_hd__decap_8
X_5743_ _1564_ _1566_ _1371_ _1374_ VGND VGND VPWR VPWR _1568_ sky130_fd_sc_hd__o211ai_2
XFILLER_50_657 VPWR VGND VPWR VGND sky130_ef_sc_hd__decap_12
X_5674_ _1489_ _1490_ _1491_ VGND VGND VPWR VPWR _1492_ sky130_fd_sc_hd__or3_1
X_4625_ _0385_ _0386_ _0353_ VGND VGND VPWR VPWR _0388_ sky130_fd_sc_hd__a21oi_1
X_4556_ _0312_ _0319_ VGND VGND VPWR VPWR _0320_ sky130_fd_sc_hd__xor2_2
X_3507_ net179 _1212_ VGND VGND VPWR VPWR _1876_ sky130_fd_sc_hd__nor2_1
XFILLER_104_637 VGND VGND VPWR VPWR sky130_fd_sc_hd__decap_6
X_4487_ net358 net363 _0250_ _0251_ VGND VGND VPWR VPWR _0252_ sky130_fd_sc_hd__a22o_1
XFILLER_89_337 VGND VGND VPWR VPWR sky130_fd_sc_hd__fill_1
XFILLER_89_315 VGND VGND VPWR VPWR sky130_fd_sc_hd__fill_2
XFILLER_103_125 VGND VGND VPWR VPWR sky130_fd_sc_hd__decap_8
X_3438_ net67 net179 VGND VGND VPWR VPWR _1124_ sky130_fd_sc_hd__nand2_1
X_6226_ _2091_ _2092_ _2087_ VGND VGND VPWR VPWR _2094_ sky130_fd_sc_hd__a21o_1
XFILLER_112_681 VGND VGND VPWR VPWR sky130_fd_sc_hd__decap_8
XFILLER_103_169 VPWR VGND VPWR VGND sky130_ef_sc_hd__decap_12
X_6157_ net452 net254 net253 net470 VGND VGND VPWR VPWR _2019_ sky130_fd_sc_hd__a22o_1
XFILLER_111_191 VPWR VGND VPWR VGND sky130_ef_sc_hd__decap_12
XFILLER_111_180 VGND VGND VPWR VPWR sky130_fd_sc_hd__fill_2
X_5108_ _0774_ _0873_ _0875_ VGND VGND VPWR VPWR _0876_ sky130_fd_sc_hd__or3_2
X_6088_ _1901_ _1902_ _1941_ _1943_ VGND VGND VPWR VPWR _1944_ sky130_fd_sc_hd__and4bb_1
XFILLER_17_109 VGND VGND VPWR VPWR sky130_fd_sc_hd__decap_3
X_5039_ net394 net339 VGND VGND VPWR VPWR _0800_ sky130_fd_sc_hd__and2_1
XTAP_TAPCELL_ROW_56_925 VGND VPWR sky130_fd_sc_hd__tapvpwrvgnd_1
XFILLER_82_27 VGND VGND VPWR VPWR sky130_fd_sc_hd__fill_1
XTAP_TAPCELL_ROW_0_241 VGND VPWR sky130_fd_sc_hd__tapvpwrvgnd_1
XTAP_TAPCELL_ROW_0_252 VGND VPWR sky130_fd_sc_hd__tapvpwrvgnd_1
XFILLER_26_643 VGND VGND VPWR VPWR sky130_fd_sc_hd__fill_1
XFILLER_25_175 VPWR VGND VPWR VGND sky130_ef_sc_hd__decap_12
XFILLER_15_65 VGND VGND VPWR VPWR sky130_fd_sc_hd__fill_2
XTAP_TAPCELL_ROW_36_682 VGND VPWR sky130_fd_sc_hd__tapvpwrvgnd_1
XFILLER_9_308 VGND VGND VPWR VPWR sky130_fd_sc_hd__decap_8
XTAP_TAPCELL_ROW_97_1415 VGND VPWR sky130_fd_sc_hd__tapvpwrvgnd_1
XTAP_TAPCELL_ROW_8_352 VGND VPWR sky130_fd_sc_hd__tapvpwrvgnd_1
Xoutput86 net86 VGND VGND VPWR VPWR return_port[18] sky130_fd_sc_hd__clkbuf_4
Xoutput97 net97 VGND VGND VPWR VPWR return_port[28] sky130_fd_sc_hd__clkbuf_4
XFILLER_0_274 VGND VGND VPWR VPWR sky130_fd_sc_hd__decap_6
XFILLER_0_296 VPWR VGND VPWR VGND sky130_ef_sc_hd__decap_12
XFILLER_91_502 VGND VGND VPWR VPWR sky130_fd_sc_hd__fill_2
XFILLER_76_587 VGND VGND VPWR VPWR sky130_fd_sc_hd__fill_1
XFILLER_91_524 VGND VGND VPWR VPWR sky130_fd_sc_hd__decap_4
XFILLER_29_481 VPWR VGND VPWR VGND sky130_ef_sc_hd__decap_12
XTAP_TAPCELL_ROW_106_1522 VGND VPWR sky130_fd_sc_hd__tapvpwrvgnd_1
XFILLER_17_665 VGND VGND VPWR VPWR sky130_fd_sc_hd__decap_6
XFILLER_16_153 VGND VGND VPWR VPWR sky130_fd_sc_hd__decap_8
XFILLER_32_613 VPWR VGND VPWR VGND sky130_ef_sc_hd__decap_12
XFILLER_16_197 VPWR VGND VPWR VGND sky130_ef_sc_hd__decap_12
XFILLER_32_657 VPWR VGND VPWR VGND sky130_ef_sc_hd__decap_12
XFILLER_31_167 VGND VGND VPWR VPWR sky130_fd_sc_hd__fill_1
X_4410_ _0141_ _0176_ VGND VGND VPWR VPWR _0177_ sky130_fd_sc_hd__nand2_1
XFILLER_8_385 VGND VGND VPWR VPWR sky130_fd_sc_hd__decap_3
X_5390_ _1061_ _1068_ _1067_ VGND VGND VPWR VPWR _1183_ sky130_fd_sc_hd__o21a_1
X_4341_ _0092_ _0108_ VGND VGND VPWR VPWR _0110_ sky130_fd_sc_hd__xnor2_1
X_4272_ _alu_i0.Controller_i._present_state\[1\] _alu_i0.Controller_i._present_state\[0\]
+ _alu_i0.Controller_i._present_state\[2\] VGND VGND VPWR VPWR _0046_ sky130_fd_sc_hd__or3b_1
Xfanout309 net310 VGND VGND VPWR VPWR net309 sky130_fd_sc_hd__clkbuf_4
XFILLER_101_629 VPWR VGND VPWR VGND sky130_ef_sc_hd__decap_12
XFILLER_86_329 VPWR VGND VPWR VGND sky130_ef_sc_hd__decap_12
X_6011_ _1711_ _1715_ _1856_ _1857_ VGND VGND VPWR VPWR _1860_ sky130_fd_sc_hd__a211oi_1
XFILLER_100_128 VPWR VGND VPWR VGND sky130_ef_sc_hd__decap_12
XFILLER_94_351 VGND VGND VPWR VPWR sky130_fd_sc_hd__decap_8
XFILLER_82_524 VGND VGND VPWR VPWR sky130_fd_sc_hd__decap_8
XFILLER_82_557 VPWR VGND VPWR VGND sky130_ef_sc_hd__decap_12
XTAP_TAPCELL_ROW_81_1227 VGND VPWR sky130_fd_sc_hd__tapvpwrvgnd_1
X_6844_ net464 net460 net330 net323 VGND VGND VPWR VPWR _2769_ sky130_fd_sc_hd__nand4_1
XFILLER_50_421 VPWR VGND VPWR VGND sky130_ef_sc_hd__decap_12
XFILLER_52_19 VGND VGND VPWR VPWR sky130_fd_sc_hd__fill_1
X_3987_ _3086_ _3175_ net161 VGND VGND VPWR VPWR _3176_ sky130_fd_sc_hd__mux2_1
X_6775_ _2687_ _2692_ VGND VGND VPWR VPWR _2693_ sky130_fd_sc_hd__xnor2_1
XTAP_TAPCELL_ROW_33_652 VGND VPWR sky130_fd_sc_hd__tapvpwrvgnd_1
XTAP_TAPCELL_ROW_61_983 VGND VPWR sky130_fd_sc_hd__tapvpwrvgnd_1
XFILLER_10_318 VGND VGND VPWR VPWR sky130_fd_sc_hd__fill_1
X_5726_ net466 net212 _1546_ _1547_ VGND VGND VPWR VPWR _1549_ sky130_fd_sc_hd__a22o_1
XFILLER_108_206 VGND VGND VPWR VPWR sky130_fd_sc_hd__decap_4
X_5657_ _1471_ _1472_ VGND VGND VPWR VPWR _1474_ sky130_fd_sc_hd__and2b_1
X_4608_ _0313_ _0316_ VGND VGND VPWR VPWR _0371_ sky130_fd_sc_hd__nand2_1
X_5588_ net309 net259 net186 net341 VGND VGND VPWR VPWR _1399_ sky130_fd_sc_hd__and4_1
XFILLER_116_250 VGND VGND VPWR VPWR sky130_fd_sc_hd__fill_2
XFILLER_104_401 VPWR VGND VPWR VGND sky130_ef_sc_hd__decap_12
X_4539_ _0300_ _0301_ _0302_ VGND VGND VPWR VPWR _0303_ sky130_fd_sc_hd__and3_1
XFILLER_116_294 VGND VGND VPWR VPWR sky130_fd_sc_hd__decap_4
XTAP_TAPCELL_ROW_92_1356 VGND VPWR sky130_fd_sc_hd__tapvpwrvgnd_1
XFILLER_77_27 VGND VGND VPWR VPWR sky130_fd_sc_hd__decap_8
XFILLER_89_189 VGND VGND VPWR VPWR sky130_fd_sc_hd__decap_4
XTAP_TAPCELL_ROW_5_311 VGND VPWR sky130_fd_sc_hd__tapvpwrvgnd_1
X_6209_ _2074_ _2075_ VGND VGND VPWR VPWR _2076_ sky130_fd_sc_hd__nor2_1
XFILLER_58_565 VGND VGND VPWR VPWR sky130_fd_sc_hd__decap_3
XFILLER_73_513 VGND VGND VPWR VPWR sky130_fd_sc_hd__decap_4
XFILLER_45_204 VGND VGND VPWR VPWR sky130_fd_sc_hd__fill_1
XFILLER_14_613 VPWR VGND VPWR VGND sky130_ef_sc_hd__decap_12
XFILLER_26_53 VPWR VGND VPWR VGND sky130_ef_sc_hd__decap_12
XFILLER_14_657 VPWR VGND VPWR VGND sky130_ef_sc_hd__decap_12
XFILLER_26_97 VGND VGND VPWR VPWR sky130_fd_sc_hd__decap_8
XFILLER_41_432 VGND VGND VPWR VPWR sky130_fd_sc_hd__decap_3
XFILLER_53_281 VGND VGND VPWR VPWR sky130_fd_sc_hd__decap_6
XTAP_TAPCELL_ROW_101_1463 VGND VPWR sky130_fd_sc_hd__tapvpwrvgnd_1
XFILLER_42_41 VGND VGND VPWR VPWR sky130_fd_sc_hd__fill_2
XTAP_TAPCELL_ROW_11_379 VGND VPWR sky130_fd_sc_hd__tapvpwrvgnd_1
XFILLER_95_104 VGND VGND VPWR VPWR sky130_fd_sc_hd__decap_8
XFILLER_1_561 VPWR VGND VPWR VGND sky130_ef_sc_hd__decap_12
XTAP_TAPCELL_ROW_112_1592 VGND VPWR sky130_fd_sc_hd__tapvpwrvgnd_1
XFILLER_3_57 VPWR VGND VPWR VGND sky130_ef_sc_hd__decap_12
XFILLER_64_513 VPWR VGND VPWR VGND sky130_ef_sc_hd__decap_12
XFILLER_36_259 VGND VGND VPWR VPWR sky130_fd_sc_hd__decap_3
XTAP_TAPCELL_ROW_67_1060 VGND VPWR sky130_fd_sc_hd__tapvpwrvgnd_1
XTAP_TAPCELL_ROW_19_479 VGND VPWR sky130_fd_sc_hd__tapvpwrvgnd_1
XFILLER_51_207 VGND VGND VPWR VPWR sky130_fd_sc_hd__fill_2
XFILLER_83_92 VPWR VGND VPWR VGND sky130_ef_sc_hd__decap_12
X_4890_ net240 net227 net385 net311 VGND VGND VPWR VPWR _0649_ sky130_fd_sc_hd__nand4_1
X_3910_ net143 _3096_ _3101_ net136 VGND VGND VPWR VPWR _3102_ sky130_fd_sc_hd__o211a_1
XFILLER_32_421 VPWR VGND VPWR VGND sky130_ef_sc_hd__decap_12
X_3841_ _3026_ _3034_ VGND VGND VPWR VPWR _3036_ sky130_fd_sc_hd__or2_1
X_3772_ _1887_ _2966_ _2968_ net141 _2965_ VGND VGND VPWR VPWR _2970_ sky130_fd_sc_hd__o221a_1
XFILLER_80_3 VPWR VGND VPWR VGND sky130_ef_sc_hd__decap_12
X_6560_ _2450_ _2459_ VGND VGND VPWR VPWR _2460_ sky130_fd_sc_hd__nand2b_1
XTAP_TAPCELL_ROW_30_611 VGND VPWR sky130_fd_sc_hd__tapvpwrvgnd_1
X_5511_ _1311_ _1312_ _1273_ VGND VGND VPWR VPWR _1315_ sky130_fd_sc_hd__a21o_1
X_6491_ _2382_ _2383_ VGND VGND VPWR VPWR _2384_ sky130_fd_sc_hd__nand2_1
XFILLER_8_171 VPWR VGND VPWR VGND sky130_ef_sc_hd__decap_12
X_5442_ _1234_ _1237_ _1238_ VGND VGND VPWR VPWR _1239_ sky130_fd_sc_hd__nand3_2
X_5373_ _1160_ _1161_ _1162_ VGND VGND VPWR VPWR _1164_ sky130_fd_sc_hd__nand3_1
X_4324_ net286 net406 VGND VGND VPWR VPWR _0093_ sky130_fd_sc_hd__nand2_1
Xfanout117 _1714_ VGND VGND VPWR VPWR net117 sky130_fd_sc_hd__buf_2
Xfanout128 net130 VGND VGND VPWR VPWR net128 sky130_fd_sc_hd__clkbuf_4
XFILLER_59_329 VGND VGND VPWR VPWR sky130_fd_sc_hd__decap_6
X_4255_ net25 net57 VGND VGND VPWR VPWR _0030_ sky130_fd_sc_hd__nor2_1
X_4186_ net157 _3194_ _3365_ net120 VGND VGND VPWR VPWR _3366_ sky130_fd_sc_hd__o211a_1
XFILLER_95_671 VGND VGND VPWR VPWR sky130_fd_sc_hd__fill_1
XTAP_TAPCELL_ROW_38_711 VGND VPWR sky130_fd_sc_hd__tapvpwrvgnd_1
XFILLER_27_248 VPWR VGND VPWR VGND sky130_ef_sc_hd__decap_12
XFILLER_103_69 VPWR VGND VPWR VGND sky130_ef_sc_hd__decap_12
X_6827_ _2573_ _2583_ _2582_ VGND VGND VPWR VPWR _2751_ sky130_fd_sc_hd__a21oi_1
XFILLER_23_465 VGND VGND VPWR VPWR sky130_fd_sc_hd__fill_2
XFILLER_109_515 VPWR VGND VPWR VGND sky130_ef_sc_hd__decap_12
XFILLER_7_609 VGND VGND VPWR VPWR sky130_fd_sc_hd__decap_6
X_6758_ net277 net245 net22 net24 VGND VGND VPWR VPWR _2675_ sky130_fd_sc_hd__nand4_1
X_6689_ _2469_ _2471_ VGND VGND VPWR VPWR _2600_ sky130_fd_sc_hd__nor2_1
X_5709_ net247 net446 VGND VGND VPWR VPWR _1531_ sky130_fd_sc_hd__nand2_1
XFILLER_109_559 VGND VGND VPWR VPWR sky130_fd_sc_hd__fill_1
XFILLER_88_48 VGND VGND VPWR VPWR sky130_fd_sc_hd__fill_2
XFILLER_77_104 VGND VGND VPWR VPWR sky130_fd_sc_hd__decap_8
XFILLER_73_321 VPWR VGND VPWR VGND sky130_ef_sc_hd__decap_12
XFILLER_46_557 VGND VGND VPWR VPWR sky130_fd_sc_hd__decap_3
XFILLER_61_505 VPWR VGND VPWR VGND sky130_ef_sc_hd__decap_12
XFILLER_46_579 VGND VGND VPWR VPWR sky130_fd_sc_hd__decap_3
XTAP_TAPCELL_ROW_16_438 VGND VPWR sky130_fd_sc_hd__tapvpwrvgnd_1
XTAP_TAPCELL_ROW_16_449 VGND VPWR sky130_fd_sc_hd__tapvpwrvgnd_1
XFILLER_26_292 VGND VGND VPWR VPWR sky130_fd_sc_hd__fill_1
XFILLER_41_273 VGND VGND VPWR VPWR sky130_fd_sc_hd__decap_6
XFILLER_115_529 VPWR VGND VPWR VGND sky130_ef_sc_hd__decap_12
XTAP_TAPCELL_ROW_114_1621 VGND VPWR sky130_fd_sc_hd__tapvpwrvgnd_1
XFILLER_5_163 VGND VGND VPWR VPWR sky130_fd_sc_hd__fill_1
XFILLER_108_581 VGND VGND VPWR VPWR sky130_fd_sc_hd__decap_6
XFILLER_68_126 VPWR VGND VPWR VGND sky130_ef_sc_hd__decap_12
XFILLER_84_608 VPWR VGND VPWR VGND sky130_ef_sc_hd__decap_12
X_4040_ net145 _3225_ net138 VGND VGND VPWR VPWR _3226_ sky130_fd_sc_hd__a21o_1
XFILLER_77_671 VGND VGND VPWR VPWR sky130_fd_sc_hd__fill_1
XFILLER_37_502 VGND VGND VPWR VPWR sky130_fd_sc_hd__fill_2
XFILLER_37_524 VGND VGND VPWR VPWR sky130_fd_sc_hd__decap_3
XFILLER_64_365 VGND VGND VPWR VPWR sky130_fd_sc_hd__decap_8
XFILLER_52_516 VPWR VGND VPWR VGND sky130_ef_sc_hd__decap_12
X_5991_ _1818_ _1835_ _1836_ VGND VGND VPWR VPWR _1838_ sky130_fd_sc_hd__and3_1
X_4942_ _0473_ _0616_ _0618_ _0699_ VGND VGND VPWR VPWR _0700_ sky130_fd_sc_hd__o211a_1
XFILLER_17_281 VPWR VGND VPWR VGND sky130_ef_sc_hd__decap_12
X_4873_ net417 net335 net327 net425 VGND VGND VPWR VPWR _0632_ sky130_fd_sc_hd__a22o_1
X_6612_ net374 net266 VGND VGND VPWR VPWR _2515_ sky130_fd_sc_hd__nand2_1
X_3824_ net160 net231 _2837_ VGND VGND VPWR VPWR _3020_ sky130_fd_sc_hd__and3_1
XFILLER_20_457 VGND VGND VPWR VPWR sky130_fd_sc_hd__decap_4
X_3755_ net137 _2944_ _2952_ _2953_ VGND VGND VPWR VPWR _2954_ sky130_fd_sc_hd__o2bb2a_1
X_6543_ net277 net427 _2439_ VGND VGND VPWR VPWR _2441_ sky130_fd_sc_hd__nand3_1
X_3686_ _2456_ _2542_ _2887_ net158 VGND VGND VPWR VPWR _2888_ sky130_fd_sc_hd__a22oi_1
X_6474_ net374 net367 net271 net268 VGND VGND VPWR VPWR _2365_ sky130_fd_sc_hd__and4_1
X_5425_ net248 net467 _1104_ _1105_ net169 VGND VGND VPWR VPWR _1220_ sky130_fd_sc_hd__a32o_1
XPHY_EDGE_ROW_12_Right_12 VGND VGND VPWR VPWR sky130_fd_sc_hd__decap_3
XTAP_TAPCELL_ROW_76_1159 VGND VPWR sky130_fd_sc_hd__tapvpwrvgnd_1
XFILLER_58_29 VPWR VGND VPWR VGND sky130_ef_sc_hd__decap_12
X_5356_ net453 net420 net300 net295 VGND VGND VPWR VPWR _1145_ sky130_fd_sc_hd__and4_1
XFILLER_99_273 VGND VGND VPWR VPWR sky130_fd_sc_hd__decap_6
X_4307_ _0057_ _0075_ _0076_ VGND VGND VPWR VPWR _0077_ sky130_fd_sc_hd__and3_1
X_5287_ _0963_ _1069_ VGND VGND VPWR VPWR _1071_ sky130_fd_sc_hd__nand2_1
XFILLER_59_104 VGND VGND VPWR VPWR sky130_fd_sc_hd__decap_8
X_4238_ _0906_ net54 _3397_ VGND VGND VPWR VPWR _0014_ sky130_fd_sc_hd__a21bo_1
XFILLER_83_641 VPWR VGND VPWR VGND sky130_ef_sc_hd__decap_12
X_4169_ _3343_ _3347_ _3349_ VGND VGND VPWR VPWR _alu_i0.Datapath_i.fu_alu_33673_33851.out1\[26\]
+ sky130_fd_sc_hd__or3_1
XFILLER_83_685 VGND VGND VPWR VPWR sky130_fd_sc_hd__decap_6
XPHY_EDGE_ROW_21_Right_21 VGND VGND VPWR VPWR sky130_fd_sc_hd__decap_3
XFILLER_28_568 VPWR VGND VPWR VGND sky130_ef_sc_hd__decap_12
XFILLER_43_505 VPWR VGND VPWR VGND sky130_ef_sc_hd__decap_12
XTAP_TAPCELL_ROW_87_1299 VGND VPWR sky130_fd_sc_hd__tapvpwrvgnd_1
XFILLER_43_549 VGND VGND VPWR VPWR sky130_fd_sc_hd__decap_8
XFILLER_90_27 VGND VGND VPWR VPWR sky130_fd_sc_hd__fill_1
XFILLER_11_424 VGND VGND VPWR VPWR sky130_fd_sc_hd__decap_8
XTAP_TAPCELL_ROW_13_408 VGND VPWR sky130_fd_sc_hd__tapvpwrvgnd_1
XTAP_TAPCELL_ROW_41_739 VGND VPWR sky130_fd_sc_hd__tapvpwrvgnd_1
XPHY_EDGE_ROW_30_Right_30 VGND VGND VPWR VPWR sky130_fd_sc_hd__decap_3
XFILLER_109_389 VGND VGND VPWR VPWR sky130_fd_sc_hd__decap_3
XFILLER_105_573 VPWR VGND VPWR VGND sky130_ef_sc_hd__decap_12
XFILLER_93_416 VPWR VGND VPWR VGND sky130_ef_sc_hd__decap_12
XFILLER_59_671 VGND VGND VPWR VPWR sky130_fd_sc_hd__fill_1
Xfanout470 net1 VGND VGND VPWR VPWR net470 sky130_fd_sc_hd__buf_4
XTAP_TAPCELL_ROW_49_839 VGND VPWR sky130_fd_sc_hd__tapvpwrvgnd_1
XFILLER_93_449 VGND VGND VPWR VPWR sky130_fd_sc_hd__fill_1
XFILLER_46_365 VGND VGND VPWR VPWR sky130_fd_sc_hd__fill_1
XFILLER_46_376 VGND VGND VPWR VPWR sky130_fd_sc_hd__fill_2
XTAP_TAPCELL_ROW_29_596 VGND VPWR sky130_fd_sc_hd__tapvpwrvgnd_1
XFILLER_14_273 VPWR VGND VPWR VGND sky130_ef_sc_hd__decap_12
XFILLER_14_295 VPWR VGND VPWR VGND sky130_ef_sc_hd__decap_12
XFILLER_80_82 VGND VGND VPWR VPWR sky130_fd_sc_hd__fill_2
X_3540_ net346 _2204_ _2226_ net280 VGND VGND VPWR VPWR _2237_ sky130_fd_sc_hd__o22a_1
XFILLER_10_490 VPWR VGND VPWR VGND sky130_ef_sc_hd__decap_12
XFILLER_6_472 VGND VGND VPWR VPWR sky130_fd_sc_hd__decap_4
XFILLER_115_337 VGND VGND VPWR VPWR sky130_fd_sc_hd__fill_2
X_5210_ _0982_ _0985_ _0876_ _0878_ VGND VGND VPWR VPWR _0987_ sky130_fd_sc_hd__o211ai_2
X_3471_ net346 net25 VGND VGND VPWR VPWR _1484_ sky130_fd_sc_hd__nand2_1
XFILLER_115_359 VPWR VGND VPWR VGND sky130_ef_sc_hd__decap_12
X_6190_ _2050_ _2052_ _2053_ VGND VGND VPWR VPWR _2055_ sky130_fd_sc_hd__a21o_1
X_5141_ net387 net313 net210 net202 VGND VGND VPWR VPWR _0911_ sky130_fd_sc_hd__nand4_2
XFILLER_69_413 VPWR VGND VPWR VGND sky130_ef_sc_hd__decap_12
X_5072_ _0834_ _0835_ _0833_ VGND VGND VPWR VPWR _0836_ sky130_fd_sc_hd__a21o_1
XFILLER_96_265 VPWR VGND VPWR VGND sky130_ef_sc_hd__decap_12
XFILLER_84_438 VPWR VGND VPWR VGND sky130_ef_sc_hd__decap_12
XFILLER_56_129 VGND VGND VPWR VPWR sky130_fd_sc_hd__decap_8
X_4023_ _0841_ net293 _3209_ VGND VGND VPWR VPWR _3210_ sky130_fd_sc_hd__o21ba_1
XFILLER_65_641 VPWR VGND VPWR VGND sky130_ef_sc_hd__decap_12
XFILLER_65_685 VGND VGND VPWR VPWR sky130_fd_sc_hd__decap_6
XFILLER_64_151 VPWR VGND VPWR VGND sky130_ef_sc_hd__decap_12
X_5974_ _1678_ _1682_ VGND VGND VPWR VPWR _1820_ sky130_fd_sc_hd__nand2_1
XFILLER_100_15 VPWR VGND VPWR VGND sky130_ef_sc_hd__decap_12
X_4925_ _0683_ VGND VGND VPWR VPWR _0684_ sky130_fd_sc_hd__inv_2
X_4856_ _0469_ _0471_ _0537_ _0539_ VGND VGND VPWR VPWR _0616_ sky130_fd_sc_hd__or4_1
XFILLER_20_221 VPWR VGND VPWR VGND sky130_ef_sc_hd__decap_12
X_3807_ net383 net337 VGND VGND VPWR VPWR _3003_ sky130_fd_sc_hd__and2_2
X_4787_ _0545_ _0546_ VGND VGND VPWR VPWR _0547_ sky130_fd_sc_hd__and2b_1
X_6526_ _2420_ _2421_ VGND VGND VPWR VPWR _2422_ sky130_fd_sc_hd__nor2_1
X_3738_ _2837_ _2937_ net160 VGND VGND VPWR VPWR _2938_ sky130_fd_sc_hd__mux2_1
XFILLER_109_57 VPWR VGND VPWR VGND sky130_ef_sc_hd__decap_12
X_3669_ net398 net214 VGND VGND VPWR VPWR _2871_ sky130_fd_sc_hd__or2_2
X_6457_ _2344_ _2345_ VGND VGND VPWR VPWR _2347_ sky130_fd_sc_hd__nor2_1
X_5408_ _1199_ _1200_ _1085_ _1087_ VGND VGND VPWR VPWR _1203_ sky130_fd_sc_hd__a211oi_1
X_6388_ _2271_ _2269_ VGND VGND VPWR VPWR _2272_ sky130_fd_sc_hd__nand2b_1
XFILLER_102_510 VGND VGND VPWR VPWR sky130_fd_sc_hd__decap_8
XFILLER_87_221 VGND VGND VPWR VPWR sky130_fd_sc_hd__decap_3
X_5339_ _1123_ _1125_ _1120_ VGND VGND VPWR VPWR _1127_ sky130_fd_sc_hd__a21o_1
XFILLER_48_608 VGND VGND VPWR VPWR sky130_fd_sc_hd__fill_1
XTAP_TAPCELL_ROW_89_1317 VGND VPWR sky130_fd_sc_hd__tapvpwrvgnd_1
XFILLER_85_49 VGND VGND VPWR VPWR sky130_fd_sc_hd__fill_1
XFILLER_75_405 VPWR VGND VPWR VGND sky130_ef_sc_hd__decap_12
XFILLER_90_419 VGND VGND VPWR VPWR sky130_fd_sc_hd__fill_1
XFILLER_18_65 VPWR VGND VPWR VGND sky130_ef_sc_hd__decap_12
XFILLER_28_365 VPWR VGND VPWR VGND sky130_ef_sc_hd__decap_12
XTAP_TAPCELL_ROW_46_809 VGND VPWR sky130_fd_sc_hd__tapvpwrvgnd_1
XFILLER_71_622 VPWR VGND VPWR VGND sky130_ef_sc_hd__decap_12
XFILLER_43_324 VPWR VGND VPWR VGND sky130_ef_sc_hd__decap_12
XFILLER_70_165 VGND VGND VPWR VPWR sky130_fd_sc_hd__decap_3
XTAP_TAPCELL_ROW_54_897 VGND VPWR sky130_fd_sc_hd__tapvpwrvgnd_1
XTAP_TAPCELL_ROW_26_566 VGND VPWR sky130_fd_sc_hd__tapvpwrvgnd_1
XFILLER_34_53 VPWR VGND VPWR VGND sky130_ef_sc_hd__decap_12
XFILLER_11_232 VGND VGND VPWR VPWR sky130_fd_sc_hd__fill_2
XFILLER_50_85 VGND VGND VPWR VPWR sky130_fd_sc_hd__fill_1
XFILLER_3_431 VPWR VGND VPWR VGND sky130_ef_sc_hd__decap_12
XFILLER_78_221 VPWR VGND VPWR VGND sky130_ef_sc_hd__decap_12
XFILLER_78_265 VPWR VGND VPWR VGND sky130_ef_sc_hd__decap_12
XFILLER_19_332 VGND VGND VPWR VPWR sky130_fd_sc_hd__decap_4
XTAP_TAPCELL_ROW_109_1564 VGND VPWR sky130_fd_sc_hd__tapvpwrvgnd_1
XFILLER_93_279 VGND VGND VPWR VPWR sky130_fd_sc_hd__fill_1
XFILLER_19_365 VPWR VGND VPWR VGND sky130_ef_sc_hd__decap_12
XFILLER_47_663 VGND VGND VPWR VPWR sky130_fd_sc_hd__decap_8
XFILLER_47_685 VGND VGND VPWR VPWR sky130_fd_sc_hd__decap_6
XFILLER_46_195 VGND VGND VPWR VPWR sky130_fd_sc_hd__fill_1
X_4710_ _0469_ _0471_ VGND VGND VPWR VPWR _0472_ sky130_fd_sc_hd__nor2_1
X_5690_ _1500_ _1507_ _1508_ VGND VGND VPWR VPWR _1510_ sky130_fd_sc_hd__nand3_1
X_4641_ _0402_ _0403_ VGND VGND VPWR VPWR _0404_ sky130_fd_sc_hd__and2b_1
XFILLER_30_585 VGND VGND VPWR VPWR sky130_fd_sc_hd__decap_3
X_4572_ _0334_ _0335_ VGND VGND VPWR VPWR _0336_ sky130_fd_sc_hd__nand2_1
XFILLER_116_657 VPWR VGND VPWR VGND sky130_ef_sc_hd__decap_12
X_3523_ net350 _0841_ _2040_ VGND VGND VPWR VPWR _2051_ sky130_fd_sc_hd__o21ai_1
X_6311_ net397 net266 _2185_ VGND VGND VPWR VPWR _2187_ sky130_fd_sc_hd__and3_1
X_3454_ net165 net170 _1288_ VGND VGND VPWR VPWR _1299_ sky130_fd_sc_hd__a21bo_1
XTAP_TAPCELL_ROW_73_1129 VGND VPWR sky130_fd_sc_hd__tapvpwrvgnd_1
XFILLER_6_291 VGND VGND VPWR VPWR sky130_fd_sc_hd__fill_1
X_6242_ net235 net223 net16 net439 VGND VGND VPWR VPWR _2112_ sky130_fd_sc_hd__and4_1
XFILLER_103_329 VGND VGND VPWR VPWR sky130_fd_sc_hd__fill_1
X_6173_ _2034_ _2035_ VGND VGND VPWR VPWR _2036_ sky130_fd_sc_hd__and2_1
XFILLER_97_585 VPWR VGND VPWR VGND sky130_ef_sc_hd__decap_12
X_5124_ net252 net170 VGND VGND VPWR VPWR _0892_ sky130_fd_sc_hd__and2_1
XFILLER_57_405 VPWR VGND VPWR VGND sky130_ef_sc_hd__decap_12
XFILLER_84_235 VPWR VGND VPWR VGND sky130_ef_sc_hd__decap_12
XFILLER_84_213 VGND VGND VPWR VPWR sky130_fd_sc_hd__fill_1
X_5055_ net425 net321 _0705_ _0704_ VGND VGND VPWR VPWR _0817_ sky130_fd_sc_hd__a31o_1
XFILLER_57_449 VGND VGND VPWR VPWR sky130_fd_sc_hd__decap_3
XFILLER_72_419 VGND VGND VPWR VPWR sky130_fd_sc_hd__fill_1
X_4006_ _3105_ _3193_ net158 VGND VGND VPWR VPWR _3194_ sky130_fd_sc_hd__mux2_1
XTAP_TAPCELL_ROW_84_1258 VGND VPWR sky130_fd_sc_hd__tapvpwrvgnd_1
XFILLER_80_452 VPWR VGND VPWR VGND sky130_ef_sc_hd__decap_12
XFILLER_52_121 VPWR VGND VPWR VGND sky130_ef_sc_hd__decap_12
XFILLER_111_69 VPWR VGND VPWR VGND sky130_ef_sc_hd__decap_12
X_5957_ net237 net224 net447 net443 VGND VGND VPWR VPWR _1802_ sky130_fd_sc_hd__and4_1
X_4908_ net433 net216 _0664_ _0665_ VGND VGND VPWR VPWR _0667_ sky130_fd_sc_hd__nand4_2
XTAP_TAPCELL_ROW_23_525 VGND VPWR sky130_fd_sc_hd__tapvpwrvgnd_1
X_5888_ _alu_i0.Datapath_i.reg_0.reg_out1\[24\] _1726_ net147 VGND VGND VPWR VPWR
+ net93 sky130_fd_sc_hd__mux2_1
XTAP_TAPCELL_ROW_51_867 VGND VPWR sky130_fd_sc_hd__tapvpwrvgnd_1
X_4839_ _0595_ _0596_ _0577_ VGND VGND VPWR VPWR _0599_ sky130_fd_sc_hd__a21oi_1
X_6509_ _2198_ _2201_ _2199_ VGND VGND VPWR VPWR _2404_ sky130_fd_sc_hd__o21ba_1
XTAP_TAPCELL_ROW_95_1387 VGND VPWR sky130_fd_sc_hd__tapvpwrvgnd_1
XFILLER_106_189 VGND VGND VPWR VPWR sky130_fd_sc_hd__decap_6
XFILLER_96_15 VPWR VGND VPWR VGND sky130_ef_sc_hd__decap_12
XFILLER_102_362 VGND VGND VPWR VPWR sky130_fd_sc_hd__fill_2
XFILLER_0_489 VPWR VGND VPWR VGND sky130_ef_sc_hd__decap_12
XFILLER_48_427 VGND VGND VPWR VPWR sky130_fd_sc_hd__fill_1
XTAP_TAPCELL_ROW_59_956 VGND VPWR sky130_fd_sc_hd__tapvpwrvgnd_1
XFILLER_75_279 VGND VGND VPWR VPWR sky130_fd_sc_hd__fill_1
XFILLER_29_641 VPWR VGND VPWR VGND sky130_ef_sc_hd__decap_12
XTAP_TAPCELL_ROW_3_283 VGND VPWR sky130_fd_sc_hd__tapvpwrvgnd_1
XFILLER_29_685 VGND VGND VPWR VPWR sky130_fd_sc_hd__decap_4
XFILLER_28_195 VGND VGND VPWR VPWR sky130_fd_sc_hd__fill_1
XFILLER_43_121 VPWR VGND VPWR VGND sky130_ef_sc_hd__decap_12
XFILLER_31_305 VGND VGND VPWR VPWR sky130_fd_sc_hd__decap_4
XFILLER_31_316 VPWR VGND VPWR VGND sky130_ef_sc_hd__decap_12
XFILLER_43_165 VGND VGND VPWR VPWR sky130_fd_sc_hd__decap_3
XTAP_TAPCELL_ROW_104_1494 VGND VPWR sky130_fd_sc_hd__tapvpwrvgnd_1
XFILLER_8_545 VPWR VGND VPWR VGND sky130_ef_sc_hd__decap_12
XFILLER_8_589 VPWR VGND VPWR VGND sky130_ef_sc_hd__decap_12
XANTENNA_6 a[29] VGND VGND VPWR VPWR sky130_fd_sc_hd__diode_2
XFILLER_3_272 VGND VGND VPWR VPWR sky130_fd_sc_hd__fill_1
XFILLER_94_500 VGND VGND VPWR VPWR sky130_fd_sc_hd__fill_1
XFILLER_94_533 VPWR VGND VPWR VGND sky130_ef_sc_hd__decap_12
XFILLER_66_213 VGND VGND VPWR VPWR sky130_fd_sc_hd__decap_6
XFILLER_39_438 VGND VGND VPWR VPWR sky130_fd_sc_hd__fill_1
XFILLER_66_257 VGND VGND VPWR VPWR sky130_fd_sc_hd__fill_1
XFILLER_54_419 VGND VGND VPWR VPWR sky130_fd_sc_hd__fill_1
XFILLER_19_140 VGND VGND VPWR VPWR sky130_fd_sc_hd__decap_4
XFILLER_81_216 VGND VGND VPWR VPWR sky130_fd_sc_hd__decap_8
XFILLER_19_151 VPWR VGND VPWR VGND sky130_ef_sc_hd__decap_12
X_6860_ _2599_ _2644_ _2598_ VGND VGND VPWR VPWR _2787_ sky130_fd_sc_hd__a21o_1
XFILLER_19_184 VGND VGND VPWR VPWR sky130_fd_sc_hd__decap_3
X_5811_ _1500_ _1508_ _1507_ VGND VGND VPWR VPWR _1642_ sky130_fd_sc_hd__a21bo_1
X_6791_ net397 net255 VGND VGND VPWR VPWR _2711_ sky130_fd_sc_hd__nand2_1
XFILLER_50_625 VPWR VGND VPWR VGND sky130_ef_sc_hd__decap_12
X_5742_ _1371_ _1374_ _1564_ _1566_ VGND VGND VPWR VPWR _1567_ sky130_fd_sc_hd__a211o_1
XFILLER_50_669 VPWR VGND VPWR VGND sky130_ef_sc_hd__decap_12
X_5673_ net309 net337 VGND VGND VPWR VPWR _1491_ sky130_fd_sc_hd__nand2_1
X_4624_ _0353_ _0385_ _0386_ VGND VGND VPWR VPWR _0387_ sky130_fd_sc_hd__and3_1
XPHY_EDGE_ROW_6_Right_6 VGND VGND VPWR VPWR sky130_fd_sc_hd__decap_3
XFILLER_116_421 VGND VGND VPWR VPWR sky130_fd_sc_hd__decap_4
X_4555_ _0317_ _0318_ VGND VGND VPWR VPWR _0319_ sky130_fd_sc_hd__nand2_1
X_3506_ net285 net454 VGND VGND VPWR VPWR _1865_ sky130_fd_sc_hd__nand2_1
X_4486_ _0248_ _0249_ _0238_ VGND VGND VPWR VPWR _0251_ sky130_fd_sc_hd__a21o_1
XFILLER_103_148 VGND VGND VPWR VPWR sky130_fd_sc_hd__decap_8
X_3437_ net68 net69 _1015_ VGND VGND VPWR VPWR _1113_ sky130_fd_sc_hd__or3_2
X_6225_ _2087_ _2091_ _2092_ VGND VGND VPWR VPWR _2093_ sky130_fd_sc_hd__nand3_2
XFILLER_97_360 VPWR VGND VPWR VGND sky130_ef_sc_hd__decap_12
X_6156_ _alu_i0.Datapath_i.reg_0.reg_out1\[27\] net147 VGND VGND VPWR VPWR _2017_
+ sky130_fd_sc_hd__nor2_1
XFILLER_97_393 VPWR VGND VPWR VGND sky130_ef_sc_hd__decap_12
X_5107_ _0871_ _0872_ _0829_ VGND VGND VPWR VPWR _0875_ sky130_fd_sc_hd__a21oi_1
XFILLER_66_29 VGND VGND VPWR VPWR sky130_fd_sc_hd__decap_4
X_6087_ _1938_ _1940_ _1786_ _1788_ VGND VGND VPWR VPWR _1943_ sky130_fd_sc_hd__o211ai_1
X_5038_ _0794_ _0798_ VGND VGND VPWR VPWR _0799_ sky130_fd_sc_hd__xnor2_1
XTAP_TAPCELL_ROW_56_926 VGND VPWR sky130_fd_sc_hd__tapvpwrvgnd_1
XTAP_TAPCELL_ROW_0_242 VGND VPWR sky130_fd_sc_hd__tapvpwrvgnd_1
XTAP_TAPCELL_ROW_0_253 VGND VPWR sky130_fd_sc_hd__tapvpwrvgnd_1
XFILLER_25_110 VGND VGND VPWR VPWR sky130_fd_sc_hd__fill_2
XFILLER_25_121 VGND VGND VPWR VPWR sky130_fd_sc_hd__decap_3
XFILLER_53_485 VGND VGND VPWR VPWR sky130_fd_sc_hd__decap_4
XFILLER_53_474 VGND VGND VPWR VPWR sky130_fd_sc_hd__decap_4
XFILLER_53_463 VGND VGND VPWR VPWR sky130_fd_sc_hd__fill_1
XFILLER_15_55 VGND VGND VPWR VPWR sky130_fd_sc_hd__fill_1
XFILLER_25_187 VPWR VGND VPWR VGND sky130_ef_sc_hd__decap_12
XTAP_TAPCELL_ROW_36_683 VGND VPWR sky130_fd_sc_hd__tapvpwrvgnd_1
XFILLER_40_124 VPWR VGND VPWR VGND sky130_ef_sc_hd__decap_12
XTAP_TAPCELL_ROW_97_1416 VGND VPWR sky130_fd_sc_hd__tapvpwrvgnd_1
XFILLER_21_393 VPWR VGND VPWR VGND sky130_ef_sc_hd__decap_12
XFILLER_110_3 VPWR VGND VPWR VGND sky130_ef_sc_hd__decap_12
XFILLER_5_559 VGND VGND VPWR VPWR sky130_fd_sc_hd__fill_1
Xoutput76 net76 VGND VGND VPWR VPWR done_port sky130_fd_sc_hd__clkbuf_4
XTAP_TAPCELL_ROW_8_353 VGND VPWR sky130_fd_sc_hd__tapvpwrvgnd_1
XTAP_TAPCELL_ROW_8_342 VGND VPWR sky130_fd_sc_hd__tapvpwrvgnd_1
Xoutput87 net87 VGND VGND VPWR VPWR return_port[19] sky130_fd_sc_hd__clkbuf_4
XFILLER_103_671 VGND VGND VPWR VPWR sky130_fd_sc_hd__fill_1
XFILLER_0_242 VGND VGND VPWR VPWR sky130_fd_sc_hd__fill_1
Xoutput98 net98 VGND VGND VPWR VPWR return_port[29] sky130_fd_sc_hd__clkbuf_4
XFILLER_76_533 VPWR VGND VPWR VGND sky130_ef_sc_hd__decap_12
XFILLER_56_62 VGND VGND VPWR VPWR sky130_fd_sc_hd__fill_2
XFILLER_56_51 VGND VGND VPWR VPWR sky130_fd_sc_hd__fill_1
XFILLER_36_419 VGND VGND VPWR VPWR sky130_fd_sc_hd__fill_1
XFILLER_48_279 VGND VGND VPWR VPWR sky130_fd_sc_hd__fill_1
XTAP_TAPCELL_ROW_106_1523 VGND VPWR sky130_fd_sc_hd__tapvpwrvgnd_1
XFILLER_16_121 VGND VGND VPWR VPWR sky130_fd_sc_hd__fill_1
XFILLER_29_493 VGND VGND VPWR VPWR sky130_fd_sc_hd__fill_2
XFILLER_72_50 VGND VGND VPWR VPWR sky130_fd_sc_hd__fill_2
XFILLER_31_113 VPWR VGND VPWR VGND sky130_ef_sc_hd__decap_12
XFILLER_32_625 VPWR VGND VPWR VGND sky130_ef_sc_hd__decap_12
XFILLER_44_485 VGND VGND VPWR VPWR sky130_fd_sc_hd__fill_2
XFILLER_32_669 VPWR VGND VPWR VGND sky130_ef_sc_hd__decap_12
XPHY_EDGE_ROW_59_Right_59 VGND VGND VPWR VPWR sky130_fd_sc_hd__decap_3
XFILLER_31_179 VGND VGND VPWR VPWR sky130_fd_sc_hd__fill_1
XFILLER_12_393 VGND VGND VPWR VPWR sky130_fd_sc_hd__fill_1
X_4340_ net471 net214 _0108_ VGND VGND VPWR VPWR _0109_ sky130_fd_sc_hd__and3_1
X_4271_ _alu_i0.Controller_i._present_state\[1\] _alu_i0.Controller_i._present_state\[0\]
+ _alu_i0.Controller_i._present_state\[2\] VGND VGND VPWR VPWR _0045_ sky130_fd_sc_hd__nor3b_4
XFILLER_4_581 VGND VGND VPWR VPWR sky130_fd_sc_hd__decap_6
X_6010_ _1858_ VGND VGND VPWR VPWR _1859_ sky130_fd_sc_hd__inv_2
XFILLER_79_393 VPWR VGND VPWR VGND sky130_ef_sc_hd__decap_12
XPHY_EDGE_ROW_68_Right_68 VGND VGND VPWR VPWR sky130_fd_sc_hd__decap_3
XFILLER_39_202 VGND VGND VPWR VPWR sky130_fd_sc_hd__fill_2
XFILLER_67_566 VGND VGND VPWR VPWR sky130_fd_sc_hd__fill_1
XFILLER_39_246 VPWR VGND VPWR VGND sky130_ef_sc_hd__decap_12
XFILLER_94_363 VGND VGND VPWR VPWR sky130_fd_sc_hd__fill_1
XFILLER_67_588 VPWR VGND VPWR VGND sky130_ef_sc_hd__decap_12
XFILLER_39_279 VGND VGND VPWR VPWR sky130_fd_sc_hd__fill_1
XFILLER_82_569 VPWR VGND VPWR VGND sky130_ef_sc_hd__decap_12
XFILLER_54_249 VGND VGND VPWR VPWR sky130_fd_sc_hd__decap_3
X_6843_ net460 net330 net323 net464 VGND VGND VPWR VPWR _2768_ sky130_fd_sc_hd__a22o_1
XTAP_TAPCELL_ROW_81_1228 VGND VPWR sky130_fd_sc_hd__tapvpwrvgnd_1
XFILLER_50_433 VGND VGND VPWR VPWR sky130_fd_sc_hd__fill_1
XPHY_EDGE_ROW_77_Right_77 VGND VGND VPWR VPWR sky130_fd_sc_hd__decap_3
X_3986_ net465 net167 net170 net176 net347 net282 VGND VGND VPWR VPWR _3175_ sky130_fd_sc_hd__mux4_1
XTAP_TAPCELL_ROW_33_642 VGND VPWR sky130_fd_sc_hd__tapvpwrvgnd_1
XTAP_TAPCELL_ROW_33_653 VGND VPWR sky130_fd_sc_hd__tapvpwrvgnd_1
X_6774_ _2686_ _2691_ VGND VGND VPWR VPWR _2692_ sky130_fd_sc_hd__xnor2_1
XTAP_TAPCELL_ROW_61_984 VGND VPWR sky130_fd_sc_hd__tapvpwrvgnd_1
X_5725_ net466 net212 _1546_ _1547_ VGND VGND VPWR VPWR _1548_ sky130_fd_sc_hd__nand4_2
X_5656_ net396 net299 net294 net404 VGND VGND VPWR VPWR _1472_ sky130_fd_sc_hd__a22o_1
XFILLER_31_691 VGND VGND VPWR VPWR sky130_fd_sc_hd__fill_1
X_4607_ _0312_ _0318_ _0317_ VGND VGND VPWR VPWR _0370_ sky130_fd_sc_hd__a21bo_1
X_5587_ net259 net186 net341 net309 VGND VGND VPWR VPWR _1398_ sky130_fd_sc_hd__a22oi_1
XFILLER_104_413 VGND VGND VPWR VPWR sky130_fd_sc_hd__decap_6
X_4538_ _0239_ _0241_ _0240_ VGND VGND VPWR VPWR _0302_ sky130_fd_sc_hd__a21bo_1
XFILLER_89_113 VGND VGND VPWR VPWR sky130_fd_sc_hd__decap_4
X_4469_ _0211_ _0213_ VGND VGND VPWR VPWR _0234_ sky130_fd_sc_hd__and2_1
XTAP_TAPCELL_ROW_92_1357 VGND VPWR sky130_fd_sc_hd__tapvpwrvgnd_1
XPHY_EDGE_ROW_86_Right_86 VGND VGND VPWR VPWR sky130_fd_sc_hd__decap_3
XTAP_TAPCELL_ROW_5_312 VGND VPWR sky130_fd_sc_hd__tapvpwrvgnd_1
X_6208_ net174 net329 net323 net218 VGND VGND VPWR VPWR _2075_ sky130_fd_sc_hd__a22oi_1
XFILLER_58_533 VPWR VGND VPWR VGND sky130_ef_sc_hd__decap_12
XFILLER_58_522 VGND VGND VPWR VPWR sky130_fd_sc_hd__decap_8
XFILLER_85_341 VGND VGND VPWR VPWR sky130_fd_sc_hd__fill_1
X_6139_ _1947_ _1948_ _1995_ _1998_ VGND VGND VPWR VPWR _2000_ sky130_fd_sc_hd__o22a_1
XFILLER_58_599 VPWR VGND VPWR VGND sky130_ef_sc_hd__decap_12
XFILLER_18_419 VGND VGND VPWR VPWR sky130_fd_sc_hd__fill_1
XFILLER_26_65 VPWR VGND VPWR VGND sky130_ef_sc_hd__decap_12
XPHY_EDGE_ROW_95_Right_95 VGND VGND VPWR VPWR sky130_fd_sc_hd__decap_3
XFILLER_13_102 VGND VGND VPWR VPWR sky130_fd_sc_hd__decap_8
XFILLER_13_113 VPWR VGND VPWR VGND sky130_ef_sc_hd__decap_12
XFILLER_14_625 VPWR VGND VPWR VGND sky130_ef_sc_hd__decap_12
XFILLER_14_669 VPWR VGND VPWR VGND sky130_ef_sc_hd__decap_12
XTAP_TAPCELL_ROW_101_1464 VGND VPWR sky130_fd_sc_hd__tapvpwrvgnd_1
XFILLER_5_301 VPWR VGND VPWR VGND sky130_ef_sc_hd__decap_12
XPHY_EDGE_ROW_39_Left_156 VGND VGND VPWR VPWR sky130_fd_sc_hd__decap_3
XFILLER_107_295 VPWR VGND VPWR VGND sky130_ef_sc_hd__decap_12
XTAP_TAPCELL_ROW_112_1593 VGND VPWR sky130_fd_sc_hd__tapvpwrvgnd_1
XFILLER_107_90 VGND VGND VPWR VPWR sky130_fd_sc_hd__decap_3
XFILLER_95_127 VPWR VGND VPWR VGND sky130_ef_sc_hd__decap_12
XFILLER_89_691 VGND VGND VPWR VPWR sky130_fd_sc_hd__fill_1
XFILLER_3_69 VPWR VGND VPWR VGND sky130_ef_sc_hd__decap_12
XFILLER_1_573 VPWR VGND VPWR VGND sky130_ef_sc_hd__decap_12
XFILLER_49_555 VGND VGND VPWR VPWR sky130_fd_sc_hd__decap_4
XFILLER_76_363 VGND VGND VPWR VPWR sky130_fd_sc_hd__fill_1
XFILLER_64_525 VGND VGND VPWR VPWR sky130_fd_sc_hd__decap_6
XFILLER_36_216 VGND VGND VPWR VPWR sky130_fd_sc_hd__decap_8
XPHY_EDGE_ROW_48_Left_165 VGND VGND VPWR VPWR sky130_fd_sc_hd__decap_3
XTAP_TAPCELL_ROW_67_1061 VGND VPWR sky130_fd_sc_hd__tapvpwrvgnd_1
XTAP_TAPCELL_ROW_67_1050 VGND VPWR sky130_fd_sc_hd__tapvpwrvgnd_1
X_3840_ _3026_ _3034_ VGND VGND VPWR VPWR _3035_ sky130_fd_sc_hd__nand2_1
X_3771_ net127 _2966_ _2968_ net123 VGND VGND VPWR VPWR _2969_ sky130_fd_sc_hd__a22o_1
XTAP_TAPCELL_ROW_30_612 VGND VPWR sky130_fd_sc_hd__tapvpwrvgnd_1
XFILLER_32_477 VGND VGND VPWR VPWR sky130_fd_sc_hd__decap_6
X_5510_ _1273_ _1311_ _1312_ VGND VGND VPWR VPWR _1314_ sky130_fd_sc_hd__nand3_1
XFILLER_13_691 VGND VGND VPWR VPWR sky130_fd_sc_hd__fill_1
XFILLER_9_673 VPWR VGND VPWR VGND sky130_ef_sc_hd__decap_12
X_6490_ _2380_ _2381_ _2196_ _2220_ VGND VGND VPWR VPWR _2383_ sky130_fd_sc_hd__a211o_1
XPHY_EDGE_ROW_57_Left_174 VGND VGND VPWR VPWR sky130_fd_sc_hd__decap_3
XFILLER_8_183 VPWR VGND VPWR VGND sky130_ef_sc_hd__decap_12
X_5441_ net172 net212 _1235_ _1236_ VGND VGND VPWR VPWR _1238_ sky130_fd_sc_hd__nand4_2
XTAP_TAPCELL_ROW_78_1190 VGND VPWR sky130_fd_sc_hd__tapvpwrvgnd_1
X_5372_ _1161_ _1162_ _1160_ VGND VGND VPWR VPWR _1163_ sky130_fd_sc_hd__a21o_1
XFILLER_113_221 VGND VGND VPWR VPWR sky130_fd_sc_hd__decap_3
X_4323_ net471 net214 VGND VGND VPWR VPWR _0092_ sky130_fd_sc_hd__nand2_1
XFILLER_113_254 VGND VGND VPWR VPWR sky130_fd_sc_hd__decap_8
XFILLER_87_617 VPWR VGND VPWR VGND sky130_ef_sc_hd__decap_12
Xfanout118 _1714_ VGND VGND VPWR VPWR net118 sky130_fd_sc_hd__buf_2
Xfanout129 net130 VGND VGND VPWR VPWR net129 sky130_fd_sc_hd__buf_2
XFILLER_113_298 VPWR VGND VPWR VGND sky130_ef_sc_hd__decap_12
X_4254_ net25 net57 VGND VGND VPWR VPWR _0029_ sky130_fd_sc_hd__and2_1
XFILLER_101_449 VPWR VGND VPWR VGND sky130_ef_sc_hd__decap_12
X_4185_ net231 _3364_ VGND VGND VPWR VPWR _3365_ sky130_fd_sc_hd__or2_1
XFILLER_103_15 VPWR VGND VPWR VGND sky130_ef_sc_hd__decap_12
XFILLER_67_363 VGND VGND VPWR VPWR sky130_fd_sc_hd__decap_3
XPHY_EDGE_ROW_66_Left_183 VGND VGND VPWR VPWR sky130_fd_sc_hd__decap_3
XTAP_TAPCELL_ROW_38_712 VGND VPWR sky130_fd_sc_hd__tapvpwrvgnd_1
XFILLER_94_193 VGND VGND VPWR VPWR sky130_fd_sc_hd__decap_3
XFILLER_42_208 VGND VGND VPWR VPWR sky130_fd_sc_hd__decap_3
XFILLER_23_400 VPWR VGND VPWR VGND sky130_ef_sc_hd__decap_12
X_6826_ _2556_ _2592_ _2591_ VGND VGND VPWR VPWR _2749_ sky130_fd_sc_hd__o21ba_1
XFILLER_50_230 VGND VGND VPWR VPWR sky130_fd_sc_hd__decap_8
XFILLER_11_617 VPWR VGND VPWR VGND sky130_ef_sc_hd__decap_12
X_6757_ net245 net22 net24 net277 VGND VGND VPWR VPWR _2674_ sky130_fd_sc_hd__a22o_1
XFILLER_109_505 VGND VGND VPWR VPWR sky130_fd_sc_hd__decap_4
X_3969_ net119 _2270_ _2467_ _3134_ _3158_ VGND VGND VPWR VPWR _3159_ sky130_fd_sc_hd__a221o_1
XFILLER_10_149 VPWR VGND VPWR VGND sky130_ef_sc_hd__decap_12
X_5708_ net450 _1529_ _1527_ VGND VGND VPWR VPWR _1530_ sky130_fd_sc_hd__a21bo_1
XFILLER_109_527 VPWR VGND VPWR VGND sky130_ef_sc_hd__decap_12
XPHY_EDGE_ROW_75_Left_192 VGND VGND VPWR VPWR sky130_fd_sc_hd__decap_3
X_6688_ _2595_ _2596_ VGND VGND VPWR VPWR _2599_ sky130_fd_sc_hd__xnor2_1
X_5639_ _1453_ _1454_ VGND VGND VPWR VPWR _1455_ sky130_fd_sc_hd__or2_1
XFILLER_73_311 VGND VGND VPWR VPWR sky130_fd_sc_hd__fill_1
XFILLER_58_352 VPWR VGND VPWR VGND sky130_ef_sc_hd__decap_12
XFILLER_73_333 VGND VGND VPWR VPWR sky130_fd_sc_hd__decap_3
XFILLER_61_517 VPWR VGND VPWR VGND sky130_ef_sc_hd__decap_12
XTAP_TAPCELL_ROW_16_439 VGND VPWR sky130_fd_sc_hd__tapvpwrvgnd_1
XFILLER_26_260 VPWR VGND VPWR VGND sky130_ef_sc_hd__decap_12
XFILLER_14_477 VPWR VGND VPWR VGND sky130_ef_sc_hd__decap_12
XFILLER_6_643 VGND VGND VPWR VPWR sky130_fd_sc_hd__fill_1
XTAP_TAPCELL_ROW_114_1622 VGND VPWR sky130_fd_sc_hd__tapvpwrvgnd_1
XFILLER_5_175 VGND VGND VPWR VPWR sky130_fd_sc_hd__decap_3
XFILLER_96_403 VGND VGND VPWR VPWR sky130_fd_sc_hd__fill_2
XFILLER_69_617 VPWR VGND VPWR VGND sky130_ef_sc_hd__decap_12
XFILLER_69_606 VGND VGND VPWR VPWR sky130_fd_sc_hd__decap_8
XFILLER_68_138 VGND VGND VPWR VPWR sky130_fd_sc_hd__fill_2
XFILLER_64_333 VGND VGND VPWR VPWR sky130_fd_sc_hd__decap_8
X_5990_ _1835_ _1836_ _1818_ VGND VGND VPWR VPWR _1837_ sky130_fd_sc_hd__a21oi_2
X_4941_ _0613_ _0695_ _0694_ VGND VGND VPWR VPWR _0699_ sky130_fd_sc_hd__a21oi_1
XFILLER_52_528 VGND VGND VPWR VPWR sky130_fd_sc_hd__decap_4
X_4872_ net424 net417 net335 net327 VGND VGND VPWR VPWR _0631_ sky130_fd_sc_hd__nand4_1
XFILLER_17_293 VGND VGND VPWR VPWR sky130_fd_sc_hd__fill_1
X_3823_ _2937_ _3018_ net160 VGND VGND VPWR VPWR _3019_ sky130_fd_sc_hd__mux2_1
X_6611_ _2511_ _2513_ VGND VGND VPWR VPWR _2514_ sky130_fd_sc_hd__nor2_1
XTAP_TAPCELL_ROW_43_770 VGND VPWR sky130_fd_sc_hd__tapvpwrvgnd_1
X_3754_ net145 _2942_ net137 VGND VGND VPWR VPWR _2953_ sky130_fd_sc_hd__a21o_1
X_6542_ net277 net21 VGND VGND VPWR VPWR _2440_ sky130_fd_sc_hd__nand2_1
X_3685_ _2886_ _2836_ net285 VGND VGND VPWR VPWR _2887_ sky130_fd_sc_hd__mux2_1
X_6473_ net367 net273 net268 net374 VGND VGND VPWR VPWR _2364_ sky130_fd_sc_hd__a22oi_1
X_5424_ _1217_ _1218_ VGND VGND VPWR VPWR _1219_ sky130_fd_sc_hd__xor2_1
X_5355_ net470 net276 VGND VGND VPWR VPWR _1144_ sky130_fd_sc_hd__nand2_1
X_4306_ _0073_ _0074_ _2717_ VGND VGND VPWR VPWR _0076_ sky130_fd_sc_hd__a21o_1
X_5286_ _1060_ _1068_ VGND VGND VPWR VPWR _1069_ sky130_fd_sc_hd__xnor2_1
XFILLER_101_257 VPWR VGND VPWR VGND sky130_ef_sc_hd__decap_12
X_4237_ _0009_ _0011_ _0012_ net125 VGND VGND VPWR VPWR _0013_ sky130_fd_sc_hd__o211a_1
XFILLER_74_29 VGND VGND VPWR VPWR sky130_fd_sc_hd__decap_6
X_4168_ _2998_ _3134_ _3307_ _2553_ _3348_ VGND VGND VPWR VPWR _3349_ sky130_fd_sc_hd__a221o_1
XFILLER_83_653 VPWR VGND VPWR VGND sky130_ef_sc_hd__decap_12
XFILLER_82_141 VGND VGND VPWR VPWR sky130_fd_sc_hd__fill_1
X_4099_ net117 _2934_ _3276_ _3282_ VGND VGND VPWR VPWR _alu_i0.Datapath_i.fu_alu_33673_33851.out1\[23\]
+ sky130_fd_sc_hd__a22o_1
XFILLER_43_517 VGND VGND VPWR VPWR sky130_fd_sc_hd__decap_4
XFILLER_82_163 VPWR VGND VPWR VGND sky130_ef_sc_hd__decap_12
XFILLER_43_528 VPWR VGND VPWR VGND sky130_ef_sc_hd__decap_12
XPHY_EDGE_ROW_83_Left_200 VGND VGND VPWR VPWR sky130_fd_sc_hd__decap_3
X_6809_ _2510_ _2516_ _2518_ VGND VGND VPWR VPWR _2731_ sky130_fd_sc_hd__a21oi_1
XTAP_TAPCELL_ROW_13_409 VGND VPWR sky130_fd_sc_hd__tapvpwrvgnd_1
XFILLER_51_561 VPWR VGND VPWR VGND sky130_ef_sc_hd__decap_12
XFILLER_11_447 VGND VGND VPWR VPWR sky130_fd_sc_hd__fill_1
XFILLER_23_55 VGND VGND VPWR VPWR sky130_fd_sc_hd__fill_1
XFILLER_51_594 VPWR VGND VPWR VGND sky130_ef_sc_hd__decap_12
XFILLER_11_458 VGND VGND VPWR VPWR sky130_fd_sc_hd__fill_1
XFILLER_109_335 VGND VGND VPWR VPWR sky130_fd_sc_hd__fill_1
XFILLER_99_15 VPWR VGND VPWR VGND sky130_ef_sc_hd__decap_12
XFILLER_2_112 VGND VGND VPWR VPWR sky130_fd_sc_hd__fill_2
XFILLER_3_3 VPWR VGND VPWR VGND sky130_ef_sc_hd__decap_12
XFILLER_2_134 VGND VGND VPWR VPWR sky130_fd_sc_hd__decap_6
XFILLER_2_145 VGND VGND VPWR VPWR sky130_fd_sc_hd__fill_2
XFILLER_105_585 VPWR VGND VPWR VGND sky130_ef_sc_hd__decap_12
XFILLER_78_436 VGND VGND VPWR VPWR sky130_fd_sc_hd__decap_3
XFILLER_78_414 VGND VGND VPWR VPWR sky130_fd_sc_hd__decap_6
XFILLER_93_428 VGND VGND VPWR VPWR sky130_fd_sc_hd__fill_1
Xfanout471 net472 VGND VGND VPWR VPWR net471 sky130_fd_sc_hd__buf_2
Xfanout460 net461 VGND VGND VPWR VPWR net460 sky130_fd_sc_hd__buf_2
XFILLER_48_85 VPWR VGND VPWR VGND sky130_ef_sc_hd__decap_12
XFILLER_74_642 VGND VGND VPWR VPWR sky130_fd_sc_hd__fill_2
XFILLER_0_15 VPWR VGND VPWR VGND sky130_ef_sc_hd__decap_12
XFILLER_19_569 VGND VGND VPWR VPWR sky130_fd_sc_hd__decap_3
XFILLER_73_174 VGND VGND VPWR VPWR sky130_fd_sc_hd__fill_1
XTAP_TAPCELL_ROW_29_597 VGND VPWR sky130_fd_sc_hd__tapvpwrvgnd_1
XFILLER_34_539 VGND VGND VPWR VPWR sky130_fd_sc_hd__fill_1
XTAP_TAPCELL_ROW_64_1020 VGND VPWR sky130_fd_sc_hd__tapvpwrvgnd_1
XFILLER_80_50 VPWR VGND VPWR VGND sky130_ef_sc_hd__decap_12
XFILLER_14_285 VGND VGND VPWR VPWR sky130_fd_sc_hd__decap_3
XFILLER_6_484 VGND VGND VPWR VPWR sky130_fd_sc_hd__fill_2
X_3470_ net164 net427 _1462_ VGND VGND VPWR VPWR _1473_ sky130_fd_sc_hd__a21bo_1
X_5140_ net366 net194 _0796_ _0795_ VGND VGND VPWR VPWR _0910_ sky130_fd_sc_hd__a31o_1
XFILLER_69_425 VPWR VGND VPWR VGND sky130_ef_sc_hd__decap_12
XFILLER_36_3 VPWR VGND VPWR VGND sky130_ef_sc_hd__decap_12
XFILLER_96_222 VGND VGND VPWR VPWR sky130_fd_sc_hd__decap_8
X_5071_ net227 net262 net221 net240 VGND VGND VPWR VPWR _0835_ sky130_fd_sc_hd__a22o_1
XFILLER_96_277 VPWR VGND VPWR VGND sky130_ef_sc_hd__decap_12
X_4022_ _3180_ _3185_ VGND VGND VPWR VPWR _3209_ sky130_fd_sc_hd__nor2_1
XFILLER_65_653 VPWR VGND VPWR VGND sky130_ef_sc_hd__decap_12
XFILLER_64_141 VGND VGND VPWR VPWR sky130_fd_sc_hd__fill_1
XFILLER_80_612 VPWR VGND VPWR VGND sky130_ef_sc_hd__decap_12
XFILLER_64_163 VGND VGND VPWR VPWR sky130_fd_sc_hd__fill_2
XFILLER_18_580 VGND VGND VPWR VPWR sky130_fd_sc_hd__decap_8
X_5973_ _1619_ _1627_ _1625_ VGND VGND VPWR VPWR _1819_ sky130_fd_sc_hd__a21o_1
XFILLER_37_377 VGND VGND VPWR VPWR sky130_fd_sc_hd__fill_1
X_4924_ _0645_ _0681_ _0682_ VGND VGND VPWR VPWR _0683_ sky130_fd_sc_hd__nand3_1
XFILLER_80_645 VPWR VGND VPWR VGND sky130_ef_sc_hd__decap_12
XFILLER_100_27 VGND VGND VPWR VPWR sky130_fd_sc_hd__fill_1
XFILLER_80_689 VGND VGND VPWR VPWR sky130_fd_sc_hd__decap_3
XFILLER_33_561 VPWR VGND VPWR VGND sky130_ef_sc_hd__decap_12
X_4855_ _0613_ _0614_ VGND VGND VPWR VPWR _0615_ sky130_fd_sc_hd__and2b_1
XFILLER_60_380 VGND VGND VPWR VPWR sky130_fd_sc_hd__fill_1
XFILLER_20_233 VPWR VGND VPWR VGND sky130_ef_sc_hd__decap_12
XFILLER_33_583 VGND VGND VPWR VPWR sky130_fd_sc_hd__decap_8
X_4786_ net401 net190 net345 net409 VGND VGND VPWR VPWR _0546_ sky130_fd_sc_hd__a22o_1
X_3806_ net136 _3001_ net130 VGND VGND VPWR VPWR _3002_ sky130_fd_sc_hd__o21ai_1
X_3737_ _2936_ _2886_ net285 VGND VGND VPWR VPWR _2937_ sky130_fd_sc_hd__mux2_1
X_6525_ _2418_ _2419_ _2216_ _2218_ VGND VGND VPWR VPWR _2421_ sky130_fd_sc_hd__a211oi_1
XFILLER_109_69 VPWR VGND VPWR VGND sky130_ef_sc_hd__decap_12
XFILLER_106_338 VPWR VGND VPWR VGND sky130_ef_sc_hd__decap_12
XFILLER_106_327 VGND VGND VPWR VPWR sky130_fd_sc_hd__fill_1
X_3668_ net398 net214 VGND VGND VPWR VPWR _2870_ sky130_fd_sc_hd__nand2_1
X_6456_ net405 net397 net263 net256 VGND VGND VPWR VPWR _2345_ sky130_fd_sc_hd__and4_1
X_3599_ _2803_ VGND VGND VPWR VPWR _2804_ sky130_fd_sc_hd__inv_2
X_5407_ _1085_ _1087_ _1199_ _1200_ VGND VGND VPWR VPWR _1202_ sky130_fd_sc_hd__o211a_1
X_6387_ _2113_ _2115_ _2112_ VGND VGND VPWR VPWR _2271_ sky130_fd_sc_hd__o21ba_1
XFILLER_87_200 VGND VGND VPWR VPWR sky130_fd_sc_hd__decap_6
X_5338_ _1120_ _1123_ _1125_ VGND VGND VPWR VPWR _1126_ sky130_fd_sc_hd__nand3_2
XFILLER_102_533 VGND VGND VPWR VPWR sky130_fd_sc_hd__decap_6
XTAP_TAPCELL_ROW_89_1318 VGND VPWR sky130_fd_sc_hd__tapvpwrvgnd_1
XFILLER_75_417 VGND VGND VPWR VPWR sky130_fd_sc_hd__decap_8
X_5269_ net379 net332 net326 net394 VGND VGND VPWR VPWR _1051_ sky130_fd_sc_hd__a22o_1
XFILLER_56_631 VPWR VGND VPWR VGND sky130_ef_sc_hd__decap_12
XFILLER_28_322 VGND VGND VPWR VPWR sky130_fd_sc_hd__decap_3
XFILLER_18_77 VGND VGND VPWR VPWR sky130_fd_sc_hd__decap_6
XFILLER_71_634 VPWR VGND VPWR VGND sky130_ef_sc_hd__decap_12
XFILLER_28_377 VGND VGND VPWR VPWR sky130_fd_sc_hd__fill_2
XFILLER_28_388 VGND VGND VPWR VPWR sky130_fd_sc_hd__decap_6
XFILLER_70_133 VGND VGND VPWR VPWR sky130_fd_sc_hd__fill_1
XTAP_TAPCELL_ROW_54_898 VGND VPWR sky130_fd_sc_hd__tapvpwrvgnd_1
XFILLER_24_561 VPWR VGND VPWR VGND sky130_ef_sc_hd__decap_12
XTAP_TAPCELL_ROW_26_567 VGND VPWR sky130_fd_sc_hd__tapvpwrvgnd_1
XFILLER_43_369 VGND VGND VPWR VPWR sky130_fd_sc_hd__decap_3
XFILLER_11_222 VGND VGND VPWR VPWR sky130_fd_sc_hd__fill_2
XFILLER_34_65 VPWR VGND VPWR VGND sky130_ef_sc_hd__decap_12
XFILLER_51_380 VPWR VGND VPWR VGND sky130_ef_sc_hd__decap_12
XFILLER_109_110 VGND VGND VPWR VPWR sky130_fd_sc_hd__fill_2
XFILLER_50_42 VPWR VGND VPWR VGND sky130_ef_sc_hd__decap_12
XFILLER_7_259 VGND VGND VPWR VPWR sky130_fd_sc_hd__decap_3
XFILLER_3_443 VGND VGND VPWR VPWR sky130_fd_sc_hd__decap_4
XFILLER_78_233 VPWR VGND VPWR VGND sky130_ef_sc_hd__decap_12
XFILLER_39_609 VGND VGND VPWR VPWR sky130_fd_sc_hd__decap_6
XFILLER_78_277 VGND VGND VPWR VPWR sky130_fd_sc_hd__fill_2
Xfanout290 net291 VGND VGND VPWR VPWR net290 sky130_fd_sc_hd__clkbuf_2
XTAP_TAPCELL_ROW_70_1090 VGND VPWR sky130_fd_sc_hd__tapvpwrvgnd_1
XTAP_TAPCELL_ROW_109_1554 VGND VPWR sky130_fd_sc_hd__tapvpwrvgnd_1
XFILLER_46_141 VPWR VGND VPWR VGND sky130_ef_sc_hd__decap_12
XTAP_TAPCELL_ROW_109_1565 VGND VPWR sky130_fd_sc_hd__tapvpwrvgnd_1
XFILLER_62_601 VGND VGND VPWR VPWR sky130_fd_sc_hd__decap_8
XFILLER_19_377 VPWR VGND VPWR VGND sky130_ef_sc_hd__decap_12
XFILLER_46_174 VGND VGND VPWR VPWR sky130_fd_sc_hd__decap_3
XFILLER_62_645 VPWR VGND VPWR VGND sky130_ef_sc_hd__decap_12
XFILLER_61_122 VGND VGND VPWR VPWR sky130_fd_sc_hd__decap_4
XFILLER_61_111 VGND VGND VPWR VPWR sky130_fd_sc_hd__fill_1
XFILLER_62_689 VGND VGND VPWR VPWR sky130_fd_sc_hd__decap_3
XFILLER_15_561 VPWR VGND VPWR VGND sky130_ef_sc_hd__decap_12
XFILLER_61_188 VGND VGND VPWR VPWR sky130_fd_sc_hd__fill_1
XFILLER_30_531 VGND VGND VPWR VPWR sky130_fd_sc_hd__fill_1
X_4640_ _0334_ _0337_ _0400_ _0401_ VGND VGND VPWR VPWR _0403_ sky130_fd_sc_hd__a211o_1
X_4571_ _0331_ _0332_ _0333_ VGND VGND VPWR VPWR _0335_ sky130_fd_sc_hd__a21o_1
X_6310_ net397 net266 _2185_ VGND VGND VPWR VPWR _2186_ sky130_fd_sc_hd__a21oi_1
XFILLER_115_113 VPWR VGND VPWR VGND sky130_ef_sc_hd__decap_12
X_3522_ net352 net450 VGND VGND VPWR VPWR _2040_ sky130_fd_sc_hd__nand2_2
XFILLER_116_669 VGND VGND VPWR VPWR sky130_fd_sc_hd__decap_3
X_3453_ net356 net168 VGND VGND VPWR VPWR _1288_ sky130_fd_sc_hd__nand2_1
X_6241_ _2108_ _2109_ _1901_ _1944_ VGND VGND VPWR VPWR _2111_ sky130_fd_sc_hd__a211o_1
X_6172_ _1873_ _2033_ VGND VGND VPWR VPWR _2035_ sky130_fd_sc_hd__nand2_1
X_5123_ net290 net169 VGND VGND VPWR VPWR _0891_ sky130_fd_sc_hd__nand2_1
XFILLER_111_341 VGND VGND VPWR VPWR sky130_fd_sc_hd__fill_1
XFILLER_57_417 VPWR VGND VPWR VGND sky130_ef_sc_hd__decap_12
XFILLER_97_597 VPWR VGND VPWR VGND sky130_ef_sc_hd__decap_12
X_5054_ _0813_ _0814_ VGND VGND VPWR VPWR _0816_ sky130_fd_sc_hd__xnor2_1
XFILLER_29_119 VGND VGND VPWR VPWR sky130_fd_sc_hd__fill_1
XFILLER_38_620 VPWR VGND VPWR VGND sky130_ef_sc_hd__decap_12
XFILLER_84_247 VGND VGND VPWR VPWR sky130_fd_sc_hd__decap_4
X_4005_ _3192_ _3153_ net281 VGND VGND VPWR VPWR _3193_ sky130_fd_sc_hd__mux2_1
XFILLER_65_461 VPWR VGND VPWR VGND sky130_ef_sc_hd__decap_12
XFILLER_111_15 VPWR VGND VPWR VGND sky130_ef_sc_hd__decap_12
XTAP_TAPCELL_ROW_84_1259 VGND VPWR sky130_fd_sc_hd__tapvpwrvgnd_1
XFILLER_37_185 VGND VGND VPWR VPWR sky130_fd_sc_hd__fill_1
XFILLER_52_133 VGND VGND VPWR VPWR sky130_fd_sc_hd__decap_6
XFILLER_80_464 VPWR VGND VPWR VGND sky130_ef_sc_hd__decap_12
X_5956_ _1797_ net112 _1612_ _1655_ VGND VGND VPWR VPWR _1800_ sky130_fd_sc_hd__o211ai_4
X_4907_ net433 net216 _0664_ _0665_ VGND VGND VPWR VPWR _0666_ sky130_fd_sc_hd__a22o_1
X_5887_ _1719_ _1724_ VGND VGND VPWR VPWR _1726_ sky130_fd_sc_hd__xnor2_1
XTAP_TAPCELL_ROW_23_526 VGND VPWR sky130_fd_sc_hd__tapvpwrvgnd_1
X_4838_ _0577_ _0595_ _0596_ VGND VGND VPWR VPWR _0598_ sky130_fd_sc_hd__nand3_1
XTAP_TAPCELL_ROW_51_868 VGND VPWR sky130_fd_sc_hd__tapvpwrvgnd_1
X_4769_ _0527_ _0528_ _0457_ VGND VGND VPWR VPWR _0530_ sky130_fd_sc_hd__o21ai_1
X_6508_ net218 net319 _2245_ _2243_ VGND VGND VPWR VPWR _2403_ sky130_fd_sc_hd__a31o_1
XTAP_TAPCELL_ROW_95_1388 VGND VPWR sky130_fd_sc_hd__tapvpwrvgnd_1
X_6439_ _2326_ _2327_ VGND VGND VPWR VPWR _2328_ sky130_fd_sc_hd__nand2_1
XFILLER_0_402 VPWR VGND VPWR VGND sky130_ef_sc_hd__decap_12
XFILLER_115_691 VGND VGND VPWR VPWR sky130_fd_sc_hd__fill_1
XFILLER_96_27 VGND VGND VPWR VPWR sky130_fd_sc_hd__fill_1
XFILLER_88_575 VPWR VGND VPWR VGND sky130_ef_sc_hd__decap_12
XFILLER_75_225 VGND VGND VPWR VPWR sky130_fd_sc_hd__decap_4
XTAP_TAPCELL_ROW_59_957 VGND VPWR sky130_fd_sc_hd__tapvpwrvgnd_1
XFILLER_28_141 VPWR VGND VPWR VGND sky130_ef_sc_hd__decap_12
XFILLER_29_653 VPWR VGND VPWR VGND sky130_ef_sc_hd__decap_12
XFILLER_56_461 VGND VGND VPWR VPWR sky130_fd_sc_hd__fill_2
XPHY_EDGE_ROW_11_Left_128 VGND VGND VPWR VPWR sky130_fd_sc_hd__decap_3
XTAP_TAPCELL_ROW_3_284 VGND VPWR sky130_fd_sc_hd__tapvpwrvgnd_1
XFILLER_44_601 VPWR VGND VPWR VGND sky130_ef_sc_hd__decap_12
XFILLER_43_111 VGND VGND VPWR VPWR sky130_fd_sc_hd__fill_1
XFILLER_43_133 VPWR VGND VPWR VGND sky130_ef_sc_hd__decap_12
XFILLER_44_645 VPWR VGND VPWR VGND sky130_ef_sc_hd__decap_12
XFILLER_44_689 VGND VGND VPWR VPWR sky130_fd_sc_hd__decap_3
XFILLER_45_75 VGND VGND VPWR VPWR sky130_fd_sc_hd__fill_1
XFILLER_31_328 VGND VGND VPWR VPWR sky130_fd_sc_hd__decap_3
XTAP_TAPCELL_ROW_104_1495 VGND VPWR sky130_fd_sc_hd__tapvpwrvgnd_1
XFILLER_101_81 VGND VGND VPWR VPWR sky130_fd_sc_hd__decap_8
XFILLER_12_531 VGND VGND VPWR VPWR sky130_fd_sc_hd__fill_1
XFILLER_8_557 VPWR VGND VPWR VGND sky130_ef_sc_hd__decap_12
XANTENNA_7 a[31] VGND VGND VPWR VPWR sky130_fd_sc_hd__diode_2
XPHY_EDGE_ROW_20_Left_137 VGND VGND VPWR VPWR sky130_fd_sc_hd__decap_3
XFILLER_113_617 VPWR VGND VPWR VGND sky130_ef_sc_hd__decap_12
XFILLER_105_190 VGND VGND VPWR VPWR sky130_fd_sc_hd__decap_8
XFILLER_94_545 VPWR VGND VPWR VGND sky130_ef_sc_hd__decap_12
XFILLER_94_589 VPWR VGND VPWR VGND sky130_ef_sc_hd__decap_12
XFILLER_19_163 VGND VGND VPWR VPWR sky130_fd_sc_hd__decap_4
XFILLER_34_100 VPWR VGND VPWR VGND sky130_ef_sc_hd__decap_12
XFILLER_62_464 VGND VGND VPWR VPWR sky130_fd_sc_hd__decap_4
X_5810_ _1638_ _1639_ _1630_ VGND VGND VPWR VPWR _1641_ sky130_fd_sc_hd__a21o_1
X_6790_ _2705_ _2709_ VGND VGND VPWR VPWR _2710_ sky130_fd_sc_hd__xnor2_1
XFILLER_34_155 VGND VGND VPWR VPWR sky130_fd_sc_hd__fill_1
X_5741_ _1562_ _1563_ _1429_ _1432_ VGND VGND VPWR VPWR _1566_ sky130_fd_sc_hd__a211oi_1
XFILLER_50_637 VGND VGND VPWR VPWR sky130_fd_sc_hd__decap_6
X_5672_ net383 net331 net325 net2 VGND VGND VPWR VPWR _1490_ sky130_fd_sc_hd__a22oi_2
XFILLER_30_361 VGND VGND VPWR VPWR sky130_fd_sc_hd__decap_3
X_4623_ _0368_ _0369_ _0383_ _0384_ VGND VGND VPWR VPWR _0386_ sky130_fd_sc_hd__a22o_1
XFILLER_116_400 VPWR VGND VPWR VGND sky130_ef_sc_hd__decap_12
X_4554_ _0315_ _0316_ _0236_ VGND VGND VPWR VPWR _0318_ sky130_fd_sc_hd__a21o_1
X_3505_ net285 net456 VGND VGND VPWR VPWR _1855_ sky130_fd_sc_hd__and2_1
XFILLER_116_477 VPWR VGND VPWR VGND sky130_ef_sc_hd__decap_12
XFILLER_103_105 VGND VGND VPWR VPWR sky130_fd_sc_hd__decap_6
X_4485_ _0238_ _0248_ _0249_ VGND VGND VPWR VPWR _0250_ sky130_fd_sc_hd__nand3_1
X_6224_ net258 net319 _2089_ _2090_ VGND VGND VPWR VPWR _2092_ sky130_fd_sc_hd__a22o_1
X_3436_ net68 _1026_ VGND VGND VPWR VPWR _1102_ sky130_fd_sc_hd__and2b_1
XFILLER_85_501 VGND VGND VPWR VPWR sky130_fd_sc_hd__decap_3
X_6155_ _2015_ _2016_ _alu_i0.Datapath_i.reg_0.reg_out1\[26\] net149 VGND VGND VPWR
+ VPWR net95 sky130_fd_sc_hd__a2bb2o_1
XFILLER_97_372 VGND VGND VPWR VPWR sky130_fd_sc_hd__decap_3
X_5106_ _0829_ _0871_ _0872_ VGND VGND VPWR VPWR _0873_ sky130_fd_sc_hd__and3_1
XFILLER_85_523 VGND VGND VPWR VPWR sky130_fd_sc_hd__fill_1
XFILLER_57_214 VGND VGND VPWR VPWR sky130_fd_sc_hd__decap_8
X_6086_ _1786_ _1788_ _1938_ _1940_ VGND VGND VPWR VPWR _1941_ sky130_fd_sc_hd__a211o_1
X_5037_ _0795_ _0796_ VGND VGND VPWR VPWR _0798_ sky130_fd_sc_hd__and2b_1
XTAP_TAPCELL_ROW_56_927 VGND VPWR sky130_fd_sc_hd__tapvpwrvgnd_1
XFILLER_26_601 VPWR VGND VPWR VGND sky130_ef_sc_hd__decap_12
XFILLER_82_29 VPWR VGND VPWR VGND sky130_ef_sc_hd__decap_12
XTAP_TAPCELL_ROW_0_243 VGND VPWR sky130_fd_sc_hd__tapvpwrvgnd_1
XTAP_TAPCELL_ROW_0_254 VGND VPWR sky130_fd_sc_hd__tapvpwrvgnd_1
XFILLER_26_645 VPWR VGND VPWR VGND sky130_ef_sc_hd__decap_12
XFILLER_26_689 VGND VGND VPWR VPWR sky130_fd_sc_hd__decap_3
XFILLER_25_199 VPWR VGND VPWR VGND sky130_ef_sc_hd__decap_12
XTAP_TAPCELL_ROW_36_684 VGND VPWR sky130_fd_sc_hd__tapvpwrvgnd_1
X_5939_ _1773_ _1780_ _1781_ VGND VGND VPWR VPWR _1782_ sky130_fd_sc_hd__nand3_1
XFILLER_15_89 VPWR VGND VPWR VGND sky130_ef_sc_hd__decap_12
XFILLER_40_136 VGND VGND VPWR VPWR sky130_fd_sc_hd__decap_4
XFILLER_21_361 VPWR VGND VPWR VGND sky130_ef_sc_hd__decap_12
XTAP_TAPCELL_ROW_97_1417 VGND VPWR sky130_fd_sc_hd__tapvpwrvgnd_1
XFILLER_5_505 VPWR VGND VPWR VGND sky130_ef_sc_hd__decap_12
XFILLER_31_55 VGND VGND VPWR VPWR sky130_fd_sc_hd__fill_1
XFILLER_107_466 VGND VGND VPWR VPWR sky130_fd_sc_hd__decap_4
XFILLER_103_3 VPWR VGND VPWR VGND sky130_ef_sc_hd__decap_12
XTAP_TAPCELL_ROW_8_343 VGND VPWR sky130_fd_sc_hd__tapvpwrvgnd_1
XFILLER_88_361 VGND VGND VPWR VPWR sky130_fd_sc_hd__decap_3
Xoutput99 net99 VGND VGND VPWR VPWR return_port[2] sky130_fd_sc_hd__clkbuf_4
Xoutput77 net77 VGND VGND VPWR VPWR return_port[0] sky130_fd_sc_hd__clkbuf_4
Xoutput88 net88 VGND VGND VPWR VPWR return_port[1] sky130_fd_sc_hd__clkbuf_4
XFILLER_0_232 VGND VGND VPWR VPWR sky130_fd_sc_hd__fill_1
XFILLER_76_545 VPWR VGND VPWR VGND sky130_ef_sc_hd__decap_12
XTAP_TAPCELL_ROW_106_1524 VGND VPWR sky130_fd_sc_hd__tapvpwrvgnd_1
XFILLER_91_559 VGND VGND VPWR VPWR sky130_fd_sc_hd__fill_1
XFILLER_56_280 VGND VGND VPWR VPWR sky130_fd_sc_hd__fill_1
XFILLER_56_85 VGND VGND VPWR VPWR sky130_fd_sc_hd__decap_3
XFILLER_44_475 VGND VGND VPWR VPWR sky130_fd_sc_hd__fill_1
XFILLER_72_62 VPWR VGND VPWR VGND sky130_ef_sc_hd__decap_12
XFILLER_71_261 VGND VGND VPWR VPWR sky130_fd_sc_hd__decap_4
XFILLER_31_125 VPWR VGND VPWR VGND sky130_ef_sc_hd__decap_12
XFILLER_32_637 VGND VGND VPWR VPWR sky130_fd_sc_hd__decap_6
XFILLER_40_681 VGND VGND VPWR VPWR sky130_fd_sc_hd__decap_8
XFILLER_8_343 VPWR VGND VPWR VGND sky130_ef_sc_hd__decap_12
XFILLER_68_6 VPWR VGND VPWR VGND sky130_ef_sc_hd__decap_12
XFILLER_8_365 VGND VGND VPWR VPWR sky130_fd_sc_hd__decap_3
XFILLER_8_398 VPWR VGND VPWR VGND sky130_ef_sc_hd__decap_12
XFILLER_99_615 VGND VGND VPWR VPWR sky130_fd_sc_hd__fill_1
XFILLER_98_147 VGND VGND VPWR VPWR sky130_fd_sc_hd__fill_1
XFILLER_98_125 VPWR VGND VPWR VGND sky130_ef_sc_hd__decap_12
X_4270_ _0037_ _0041_ _0044_ VGND VGND VPWR VPWR _alu_i0.Datapath_i.fu_alu_33673_33851.out1\[31\]
+ sky130_fd_sc_hd__or3_1
XFILLER_101_609 VGND VGND VPWR VPWR sky130_fd_sc_hd__decap_6
XFILLER_86_309 VPWR VGND VPWR VGND sky130_ef_sc_hd__decap_12
XFILLER_39_225 VGND VGND VPWR VPWR sky130_fd_sc_hd__decap_6
XFILLER_67_556 VGND VGND VPWR VPWR sky130_fd_sc_hd__decap_4
XFILLER_39_258 VGND VGND VPWR VPWR sky130_fd_sc_hd__fill_2
XFILLER_23_615 VGND VGND VPWR VPWR sky130_fd_sc_hd__fill_1
X_6842_ net445 net442 net185 net340 VGND VGND VPWR VPWR _2767_ sky130_fd_sc_hd__nand4_1
XTAP_TAPCELL_ROW_81_1229 VGND VPWR sky130_fd_sc_hd__tapvpwrvgnd_1
XTAP_TAPCELL_ROW_81_1218 VGND VPWR sky130_fd_sc_hd__tapvpwrvgnd_1
XFILLER_22_147 VPWR VGND VPWR VGND sky130_ef_sc_hd__decap_12
XTAP_TAPCELL_ROW_33_643 VGND VPWR sky130_fd_sc_hd__tapvpwrvgnd_1
X_6773_ _2688_ _2690_ VGND VGND VPWR VPWR _2691_ sky130_fd_sc_hd__xnor2_1
XFILLER_50_467 VGND VGND VPWR VPWR sky130_fd_sc_hd__fill_1
X_3985_ net132 _3162_ _3173_ _1539_ VGND VGND VPWR VPWR _3174_ sky130_fd_sc_hd__a211o_1
XTAP_TAPCELL_ROW_61_985 VGND VPWR sky130_fd_sc_hd__tapvpwrvgnd_1
X_5724_ net168 net206 net199 net172 VGND VGND VPWR VPWR _1547_ sky130_fd_sc_hd__a22o_1
X_5655_ net404 net395 net299 net294 VGND VGND VPWR VPWR _1471_ sky130_fd_sc_hd__and4_1
X_4606_ net357 net386 _0366_ _0367_ VGND VGND VPWR VPWR _0369_ sky130_fd_sc_hd__nand4_2
X_5586_ _1394_ _1395_ VGND VGND VPWR VPWR _1396_ sky130_fd_sc_hd__or2_1
XFILLER_116_263 VGND VGND VPWR VPWR sky130_fd_sc_hd__fill_1
X_4537_ _0297_ _0298_ _0299_ VGND VGND VPWR VPWR _0301_ sky130_fd_sc_hd__nand3_1
X_4468_ _alu_i0.Datapath_i.reg_0.reg_out1\[8\] _0233_ net148 VGND VGND VPWR VPWR net107
+ sky130_fd_sc_hd__mux2_1
XTAP_TAPCELL_ROW_92_1358 VGND VPWR sky130_fd_sc_hd__tapvpwrvgnd_1
XFILLER_89_169 VGND VGND VPWR VPWR sky130_fd_sc_hd__fill_2
XTAP_TAPCELL_ROW_5_313 VGND VPWR sky130_fd_sc_hd__tapvpwrvgnd_1
X_6207_ net218 net174 net329 net323 VGND VGND VPWR VPWR _2074_ sky130_fd_sc_hd__and4_1
X_3419_ net213 VGND VGND VPWR VPWR _0917_ sky130_fd_sc_hd__inv_2
X_4399_ _0122_ _0123_ _0124_ VGND VGND VPWR VPWR _0166_ sky130_fd_sc_hd__a21bo_1
XFILLER_98_681 VGND VGND VPWR VPWR sky130_fd_sc_hd__decap_8
X_6138_ _1947_ _1948_ _1995_ _1998_ VGND VGND VPWR VPWR _1999_ sky130_fd_sc_hd__nor4_1
XFILLER_58_545 VPWR VGND VPWR VGND sky130_ef_sc_hd__decap_12
XFILLER_85_364 VPWR VGND VPWR VGND sky130_ef_sc_hd__decap_12
XFILLER_58_589 VGND VGND VPWR VPWR sky130_fd_sc_hd__decap_3
X_6069_ _1922_ VGND VGND VPWR VPWR _1923_ sky130_fd_sc_hd__inv_2
XFILLER_73_559 VGND VGND VPWR VPWR sky130_fd_sc_hd__fill_1
XFILLER_14_637 VGND VGND VPWR VPWR sky130_fd_sc_hd__decap_6
XFILLER_26_77 VGND VGND VPWR VPWR sky130_fd_sc_hd__decap_6
XFILLER_26_475 VGND VGND VPWR VPWR sky130_fd_sc_hd__fill_1
XFILLER_26_497 VGND VGND VPWR VPWR sky130_fd_sc_hd__decap_3
XFILLER_13_125 VPWR VGND VPWR VGND sky130_ef_sc_hd__decap_12
XTAP_TAPCELL_ROW_101_1465 VGND VPWR sky130_fd_sc_hd__tapvpwrvgnd_1
XFILLER_9_118 VGND VGND VPWR VPWR sky130_fd_sc_hd__decap_4
XFILLER_22_681 VGND VGND VPWR VPWR sky130_fd_sc_hd__decap_8
XFILLER_5_313 VGND VGND VPWR VPWR sky130_fd_sc_hd__decap_8
XFILLER_5_335 VGND VGND VPWR VPWR sky130_fd_sc_hd__fill_1
XFILLER_3_15 VPWR VGND VPWR VGND sky130_ef_sc_hd__decap_12
XFILLER_1_541 VPWR VGND VPWR VGND sky130_ef_sc_hd__decap_12
XTAP_TAPCELL_ROW_112_1594 VGND VPWR sky130_fd_sc_hd__tapvpwrvgnd_1
XFILLER_95_139 VGND VGND VPWR VPWR sky130_fd_sc_hd__fill_2
XFILLER_1_585 VPWR VGND VPWR VGND sky130_ef_sc_hd__decap_12
XFILLER_91_323 VGND VGND VPWR VPWR sky130_fd_sc_hd__decap_4
XPHY_EDGE_ROW_103_Left_220 VGND VGND VPWR VPWR sky130_fd_sc_hd__decap_3
XTAP_TAPCELL_ROW_67_1051 VGND VPWR sky130_fd_sc_hd__tapvpwrvgnd_1
XFILLER_17_464 VPWR VGND VPWR VGND sky130_ef_sc_hd__decap_12
XFILLER_44_272 VPWR VGND VPWR VGND sky130_ef_sc_hd__decap_12
X_3770_ _2945_ _2950_ _2967_ VGND VGND VPWR VPWR _2968_ sky130_fd_sc_hd__o21a_1
XTAP_TAPCELL_ROW_30_613 VGND VPWR sky130_fd_sc_hd__tapvpwrvgnd_1
XFILLER_9_641 VPWR VGND VPWR VGND sky130_ef_sc_hd__decap_12
XFILLER_9_685 VGND VGND VPWR VPWR sky130_fd_sc_hd__decap_6
XFILLER_8_151 VGND VGND VPWR VPWR sky130_fd_sc_hd__decap_8
X_5440_ net172 net212 _1235_ _1236_ VGND VGND VPWR VPWR _1237_ sky130_fd_sc_hd__a22o_1
XFILLER_66_3 VGND VGND VPWR VPWR sky130_fd_sc_hd__fill_1
XTAP_TAPCELL_ROW_10_370 VGND VPWR sky130_fd_sc_hd__tapvpwrvgnd_1
XFILLER_8_195 VGND VGND VPWR VPWR sky130_fd_sc_hd__fill_1
X_5371_ net368 net332 net326 net376 VGND VGND VPWR VPWR _1162_ sky130_fd_sc_hd__a22o_1
XFILLER_99_445 VGND VGND VPWR VPWR sky130_fd_sc_hd__decap_3
X_4322_ _alu_i0.Datapath_i.reg_0.reg_out1\[4\] net149 _0090_ _0091_ VGND VGND VPWR
+ VPWR net103 sky130_fd_sc_hd__a22o_1
XTAP_TAPCELL_ROW_78_1191 VGND VPWR sky130_fd_sc_hd__tapvpwrvgnd_1
XFILLER_101_406 VGND VGND VPWR VPWR sky130_fd_sc_hd__decap_8
XFILLER_87_607 VGND VGND VPWR VPWR sky130_fd_sc_hd__decap_8
Xfanout119 _1714_ VGND VGND VPWR VPWR net119 sky130_fd_sc_hd__buf_1
X_4253_ _0010_ _0015_ _0008_ VGND VGND VPWR VPWR _0028_ sky130_fd_sc_hd__o21ai_1
XFILLER_87_629 VPWR VGND VPWR VGND sky130_ef_sc_hd__decap_12
X_4184_ _3278_ _3363_ net161 VGND VGND VPWR VPWR _3364_ sky130_fd_sc_hd__mux2_1
XFILLER_95_673 VPWR VGND VPWR VGND sky130_ef_sc_hd__decap_12
XTAP_TAPCELL_ROW_38_702 VGND VPWR sky130_fd_sc_hd__tapvpwrvgnd_1
XTAP_TAPCELL_ROW_38_713 VGND VPWR sky130_fd_sc_hd__tapvpwrvgnd_1
XFILLER_103_27 VPWR VGND VPWR VGND sky130_ef_sc_hd__decap_12
XFILLER_82_312 VPWR VGND VPWR VGND sky130_ef_sc_hd__decap_12
XFILLER_67_386 VGND VGND VPWR VPWR sky130_fd_sc_hd__decap_3
XTAP_TAPCELL_ROW_18_470 VGND VPWR sky130_fd_sc_hd__tapvpwrvgnd_1
XFILLER_23_412 VGND VGND VPWR VPWR sky130_fd_sc_hd__decap_8
X_6825_ _2703_ _2747_ VGND VGND VPWR VPWR _2748_ sky130_fd_sc_hd__xnor2_1
XFILLER_11_629 VPWR VGND VPWR VGND sky130_ef_sc_hd__decap_12
X_6756_ _2631_ _2634_ VGND VGND VPWR VPWR _2672_ sky130_fd_sc_hd__nand2_1
XFILLER_50_253 VPWR VGND VPWR VGND sky130_ef_sc_hd__decap_12
X_3968_ net138 _3141_ _3143_ net132 VGND VGND VPWR VPWR _3158_ sky130_fd_sc_hd__a22o_1
XFILLER_10_139 VGND VGND VPWR VPWR sky130_fd_sc_hd__fill_1
X_5707_ net235 net223 net462 VGND VGND VPWR VPWR _1529_ sky130_fd_sc_hd__and3_1
XFILLER_50_297 VGND VGND VPWR VPWR sky130_fd_sc_hd__decap_8
XFILLER_109_539 VPWR VGND VPWR VGND sky130_ef_sc_hd__decap_12
X_3899_ _2910_ _2959_ _3090_ net118 VGND VGND VPWR VPWR _3092_ sky130_fd_sc_hd__a22o_1
X_6687_ _2595_ _2596_ VGND VGND VPWR VPWR _2598_ sky130_fd_sc_hd__and2b_1
X_5638_ _1449_ _1451_ _1326_ _1328_ VGND VGND VPWR VPWR _1454_ sky130_fd_sc_hd__o211a_1
X_5569_ _1250_ _1253_ _1376_ _1377_ VGND VGND VPWR VPWR _1378_ sky130_fd_sc_hd__o211ai_4
XFILLER_104_288 VGND VGND VPWR VPWR sky130_fd_sc_hd__decap_4
XFILLER_18_217 VGND VGND VPWR VPWR sky130_fd_sc_hd__decap_8
XFILLER_73_378 VGND VGND VPWR VPWR sky130_fd_sc_hd__fill_2
XFILLER_73_389 VGND VGND VPWR VPWR sky130_fd_sc_hd__decap_3
XFILLER_61_529 VPWR VGND VPWR VGND sky130_ef_sc_hd__decap_12
XFILLER_26_272 VPWR VGND VPWR VGND sky130_ef_sc_hd__decap_12
XFILLER_14_489 VGND VGND VPWR VPWR sky130_fd_sc_hd__fill_2
XTAP_TAPCELL_ROW_114_1623 VGND VPWR sky130_fd_sc_hd__tapvpwrvgnd_1
XFILLER_69_629 VPWR VGND VPWR VGND sky130_ef_sc_hd__decap_12
XFILLER_68_117 VGND VGND VPWR VPWR sky130_fd_sc_hd__decap_6
XFILLER_77_673 VPWR VGND VPWR VGND sky130_ef_sc_hd__decap_12
XFILLER_92_643 VGND VGND VPWR VPWR sky130_fd_sc_hd__fill_1
XFILLER_76_194 VGND VGND VPWR VPWR sky130_fd_sc_hd__fill_2
XFILLER_64_323 VGND VGND VPWR VPWR sky130_fd_sc_hd__fill_1
XFILLER_37_537 VPWR VGND VPWR VGND sky130_ef_sc_hd__decap_12
XFILLER_91_131 VPWR VGND VPWR VGND sky130_ef_sc_hd__decap_12
X_4940_ _alu_i0.Datapath_i.reg_0.reg_out1\[15\] _0698_ net146 VGND VGND VPWR VPWR
+ net83 sky130_fd_sc_hd__mux2_1
X_4871_ net410 net338 VGND VGND VPWR VPWR _0630_ sky130_fd_sc_hd__and2_1
XFILLER_45_592 VPWR VGND VPWR VGND sky130_ef_sc_hd__decap_12
X_3822_ _3017_ _2973_ net284 VGND VGND VPWR VPWR _3018_ sky130_fd_sc_hd__mux2_1
X_6610_ net397 net390 net263 net256 VGND VGND VPWR VPWR _2513_ sky130_fd_sc_hd__and4_1
XFILLER_32_253 VPWR VGND VPWR VGND sky130_ef_sc_hd__decap_12
XTAP_TAPCELL_ROW_43_771 VGND VPWR sky130_fd_sc_hd__tapvpwrvgnd_1
X_6541_ _2436_ _2437_ VGND VGND VPWR VPWR _2439_ sky130_fd_sc_hd__xnor2_1
X_3753_ net141 _2951_ _2948_ VGND VGND VPWR VPWR _2952_ sky130_fd_sc_hd__o21bai_1
X_3684_ net163 net400 _2390_ VGND VGND VPWR VPWR _2886_ sky130_fd_sc_hd__a21bo_1
X_6472_ _2361_ _2362_ VGND VGND VPWR VPWR _2363_ sky130_fd_sc_hd__xnor2_1
X_5423_ net248 net463 VGND VGND VPWR VPWR _1218_ sky130_fd_sc_hd__nand2_1
X_5354_ _1140_ _1141_ _1030_ _1033_ VGND VGND VPWR VPWR _1143_ sky130_fd_sc_hd__o211a_1
XFILLER_114_531 VGND VGND VPWR VPWR sky130_fd_sc_hd__fill_1
X_4305_ _2717_ _0073_ _0074_ VGND VGND VPWR VPWR _0075_ sky130_fd_sc_hd__nand3_1
X_5285_ _0937_ _1066_ VGND VGND VPWR VPWR _1068_ sky130_fd_sc_hd__xnor2_1
XFILLER_114_15 VPWR VGND VPWR VGND sky130_ef_sc_hd__decap_12
XFILLER_101_225 VGND VGND VPWR VPWR sky130_fd_sc_hd__decap_8
X_4236_ _0009_ _0011_ VGND VGND VPWR VPWR _0012_ sky130_fd_sc_hd__nand2_1
XFILLER_101_269 VGND VGND VPWR VPWR sky130_fd_sc_hd__decap_8
X_4167_ net128 _3334_ VGND VGND VPWR VPWR _3348_ sky130_fd_sc_hd__nor2_1
XFILLER_82_120 VGND VGND VPWR VPWR sky130_fd_sc_hd__decap_4
XFILLER_55_334 VGND VGND VPWR VPWR sky130_fd_sc_hd__fill_2
XFILLER_83_665 VGND VGND VPWR VPWR sky130_fd_sc_hd__decap_6
X_4098_ _0808_ _3280_ _3281_ net151 _1550_ VGND VGND VPWR VPWR _3282_ sky130_fd_sc_hd__a221o_1
XFILLER_82_175 VGND VGND VPWR VPWR sky130_fd_sc_hd__decap_4
XFILLER_70_304 VGND VGND VPWR VPWR sky130_fd_sc_hd__decap_4
XFILLER_82_197 VGND VGND VPWR VPWR sky130_fd_sc_hd__decap_4
XFILLER_90_29 VPWR VGND VPWR VGND sky130_ef_sc_hd__decap_12
X_6808_ _2714_ _2729_ VGND VGND VPWR VPWR _2730_ sky130_fd_sc_hd__xnor2_1
XFILLER_51_573 VPWR VGND VPWR VGND sky130_ef_sc_hd__decap_12
X_6739_ _2444_ _2448_ _2653_ _2654_ VGND VGND VPWR VPWR _2655_ sky130_fd_sc_hd__o211a_1
XFILLER_99_27 VPWR VGND VPWR VGND sky130_ef_sc_hd__decap_12
XTAP_TAPCELL_ROW_21_498 VGND VPWR sky130_fd_sc_hd__tapvpwrvgnd_1
XFILLER_105_597 VPWR VGND VPWR VGND sky130_ef_sc_hd__decap_12
Xfanout450 net13 VGND VGND VPWR VPWR net450 sky130_fd_sc_hd__clkbuf_4
Xfanout472 net473 VGND VGND VPWR VPWR net472 sky130_fd_sc_hd__buf_2
XFILLER_59_673 VPWR VGND VPWR VGND sky130_ef_sc_hd__decap_12
Xfanout461 net11 VGND VGND VPWR VPWR net461 sky130_fd_sc_hd__clkbuf_2
XFILLER_86_492 VPWR VGND VPWR VGND sky130_ef_sc_hd__decap_12
XFILLER_74_610 VPWR VGND VPWR VGND sky130_ef_sc_hd__decap_12
XFILLER_58_194 VGND VGND VPWR VPWR sky130_fd_sc_hd__fill_2
XFILLER_0_27 VGND VGND VPWR VPWR sky130_fd_sc_hd__fill_1
XFILLER_19_559 VGND VGND VPWR VPWR sky130_fd_sc_hd__fill_1
XFILLER_64_41 VGND VGND VPWR VPWR sky130_fd_sc_hd__fill_2
XFILLER_34_518 VGND VGND VPWR VPWR sky130_fd_sc_hd__decap_8
XTAP_TAPCELL_ROW_64_1021 VGND VPWR sky130_fd_sc_hd__tapvpwrvgnd_1
XFILLER_61_337 VPWR VGND VPWR VGND sky130_ef_sc_hd__decap_12
XTAP_TAPCELL_ROW_29_598 VGND VPWR sky130_fd_sc_hd__tapvpwrvgnd_1
XFILLER_80_62 VPWR VGND VPWR VGND sky130_ef_sc_hd__decap_12
XTAP_TAPCELL_ROW_40_730 VGND VPWR sky130_fd_sc_hd__tapvpwrvgnd_1
XTAP_TAPCELL_ROW_75_1150 VGND VPWR sky130_fd_sc_hd__tapvpwrvgnd_1
XFILLER_111_501 VGND VGND VPWR VPWR sky130_fd_sc_hd__decap_3
XFILLER_96_212 VGND VGND VPWR VPWR sky130_fd_sc_hd__decap_3
X_5070_ net240 net227 net261 net220 VGND VGND VPWR VPWR _0834_ sky130_fd_sc_hd__nand4_1
XFILLER_69_437 VGND VGND VPWR VPWR sky130_fd_sc_hd__decap_8
XFILLER_84_429 VGND VGND VPWR VPWR sky130_fd_sc_hd__fill_1
XFILLER_84_407 VPWR VGND VPWR VGND sky130_ef_sc_hd__decap_12
XFILLER_29_3 VPWR VGND VPWR VGND sky130_ef_sc_hd__decap_12
X_4021_ net126 _3205_ _3206_ _3207_ VGND VGND VPWR VPWR _3208_ sky130_fd_sc_hd__a31o_1
XFILLER_96_289 VPWR VGND VPWR VGND sky130_ef_sc_hd__decap_12
XTAP_TAPCELL_ROW_48_830 VGND VPWR sky130_fd_sc_hd__tapvpwrvgnd_1
XFILLER_65_665 VGND VGND VPWR VPWR sky130_fd_sc_hd__decap_6
XFILLER_80_624 VPWR VGND VPWR VGND sky130_ef_sc_hd__decap_12
X_5972_ _1816_ _1817_ VGND VGND VPWR VPWR _1818_ sky130_fd_sc_hd__nor2_1
X_4923_ _0678_ _0680_ _0595_ _0598_ VGND VGND VPWR VPWR _0682_ sky130_fd_sc_hd__o211ai_1
XFILLER_80_657 VPWR VGND VPWR VGND sky130_ef_sc_hd__decap_12
XFILLER_64_197 VGND VGND VPWR VPWR sky130_fd_sc_hd__fill_2
XFILLER_33_573 VGND VGND VPWR VPWR sky130_fd_sc_hd__decap_3
X_4854_ _0611_ _0612_ _0533_ _0535_ VGND VGND VPWR VPWR _0614_ sky130_fd_sc_hd__a211o_1
X_4785_ net409 net401 net190 net345 VGND VGND VPWR VPWR _0545_ sky130_fd_sc_hd__and4_1
X_3805_ net385 net338 VGND VGND VPWR VPWR _3001_ sky130_fd_sc_hd__nor2_1
XFILLER_20_245 VGND VGND VPWR VPWR sky130_fd_sc_hd__decap_6
X_3736_ net378 net392 net349 VGND VGND VPWR VPWR _2936_ sky130_fd_sc_hd__mux2_1
X_6524_ _2216_ _2218_ _2418_ _2419_ VGND VGND VPWR VPWR _2420_ sky130_fd_sc_hd__o211a_1
XFILLER_109_15 VPWR VGND VPWR VGND sky130_ef_sc_hd__decap_12
X_3667_ net398 net214 VGND VGND VPWR VPWR _2869_ sky130_fd_sc_hd__and2_2
X_6455_ net397 net263 net256 net405 VGND VGND VPWR VPWR _2344_ sky130_fd_sc_hd__a22oi_1
X_3598_ net141 _2800_ _2801_ _2802_ _2797_ VGND VGND VPWR VPWR _2803_ sky130_fd_sc_hd__o32a_1
X_5406_ _1197_ _1198_ _1034_ _1036_ VGND VGND VPWR VPWR _1200_ sky130_fd_sc_hd__a211o_1
X_6386_ _2267_ _2268_ VGND VGND VPWR VPWR _2269_ sky130_fd_sc_hd__xnor2_1
XFILLER_114_361 VGND VGND VPWR VPWR sky130_fd_sc_hd__decap_3
XFILLER_114_350 VGND VGND VPWR VPWR sky130_fd_sc_hd__fill_1
X_5337_ net177 net213 _1121_ _1122_ VGND VGND VPWR VPWR _1125_ sky130_fd_sc_hd__nand4_2
XFILLER_0_617 VPWR VGND VPWR VGND sky130_ef_sc_hd__decap_12
X_5268_ net394 net379 net332 net326 VGND VGND VPWR VPWR _1050_ sky130_fd_sc_hd__nand4_1
XFILLER_102_589 VPWR VGND VPWR VGND sky130_ef_sc_hd__decap_12
XTAP_TAPCELL_ROW_89_1319 VGND VPWR sky130_fd_sc_hd__tapvpwrvgnd_1
X_4219_ net427 _1004_ _3371_ _3378_ VGND VGND VPWR VPWR _3397_ sky130_fd_sc_hd__a22o_1
X_5199_ _0827_ _0974_ VGND VGND VPWR VPWR _0975_ sky130_fd_sc_hd__or2_1
XFILLER_28_301 VGND VGND VPWR VPWR sky130_fd_sc_hd__fill_2
XFILLER_56_643 VGND VGND VPWR VPWR sky130_fd_sc_hd__fill_1
XFILLER_71_646 VPWR VGND VPWR VGND sky130_ef_sc_hd__decap_12
XFILLER_43_337 VPWR VGND VPWR VGND sky130_ef_sc_hd__decap_12
XFILLER_24_573 VPWR VGND VPWR VGND sky130_ef_sc_hd__decap_12
XTAP_TAPCELL_ROW_26_568 VGND VPWR sky130_fd_sc_hd__tapvpwrvgnd_1
XTAP_TAPCELL_ROW_54_899 VGND VPWR sky130_fd_sc_hd__tapvpwrvgnd_1
XFILLER_34_77 VGND VGND VPWR VPWR sky130_fd_sc_hd__decap_6
XFILLER_34_88 VPWR VGND VPWR VGND sky130_ef_sc_hd__decap_12
XFILLER_7_205 VPWR VGND VPWR VGND sky130_ef_sc_hd__decap_12
XFILLER_109_122 VPWR VGND VPWR VGND sky130_ef_sc_hd__decap_12
XFILLER_11_289 VGND VGND VPWR VPWR sky130_fd_sc_hd__decap_3
XFILLER_50_21 VGND VGND VPWR VPWR sky130_fd_sc_hd__decap_6
XFILLER_50_54 VPWR VGND VPWR VGND sky130_ef_sc_hd__decap_12
XFILLER_109_166 VGND VGND VPWR VPWR sky130_fd_sc_hd__fill_2
XFILLER_3_411 VGND VGND VPWR VPWR sky130_fd_sc_hd__decap_4
XFILLER_112_309 VGND VGND VPWR VPWR sky130_fd_sc_hd__fill_1
XFILLER_105_383 VGND VGND VPWR VPWR sky130_fd_sc_hd__decap_8
XFILLER_78_245 VGND VGND VPWR VPWR sky130_fd_sc_hd__decap_6
XFILLER_59_85 VGND VGND VPWR VPWR sky130_fd_sc_hd__fill_1
XFILLER_59_74 VGND VGND VPWR VPWR sky130_fd_sc_hd__decap_4
Xfanout291 net44 VGND VGND VPWR VPWR net291 sky130_fd_sc_hd__clkbuf_2
Xfanout280 net281 VGND VGND VPWR VPWR net280 sky130_fd_sc_hd__clkbuf_4
XTAP_TAPCELL_ROW_70_1091 VGND VPWR sky130_fd_sc_hd__tapvpwrvgnd_1
XFILLER_19_301 VGND VGND VPWR VPWR sky130_fd_sc_hd__fill_1
XTAP_TAPCELL_ROW_109_1555 VGND VPWR sky130_fd_sc_hd__tapvpwrvgnd_1
XFILLER_75_73 VGND VGND VPWR VPWR sky130_fd_sc_hd__decap_3
XFILLER_74_484 VPWR VGND VPWR VGND sky130_ef_sc_hd__decap_12
XFILLER_62_624 VPWR VGND VPWR VGND sky130_ef_sc_hd__decap_12
XFILLER_19_389 VGND VGND VPWR VPWR sky130_fd_sc_hd__decap_3
XFILLER_46_153 VGND VGND VPWR VPWR sky130_fd_sc_hd__decap_6
XFILLER_62_657 VPWR VGND VPWR VGND sky130_ef_sc_hd__decap_12
XFILLER_61_134 VGND VGND VPWR VPWR sky130_fd_sc_hd__decap_4
XFILLER_61_167 VGND VGND VPWR VPWR sky130_fd_sc_hd__fill_1
XFILLER_15_573 VPWR VGND VPWR VGND sky130_ef_sc_hd__decap_12
X_4570_ _0331_ _0332_ _0333_ VGND VGND VPWR VPWR _0334_ sky130_fd_sc_hd__nand3_1
XFILLER_116_604 VGND VGND VPWR VPWR sky130_fd_sc_hd__decap_3
X_3521_ net163 net167 _2018_ VGND VGND VPWR VPWR _2029_ sky130_fd_sc_hd__a21bo_1
XFILLER_115_125 VPWR VGND VPWR VGND sky130_ef_sc_hd__decap_12
X_3452_ net222 _1244_ VGND VGND VPWR VPWR _1277_ sky130_fd_sc_hd__nand2_1
X_6240_ _1901_ _1944_ _2108_ _2109_ VGND VGND VPWR VPWR _2110_ sky130_fd_sc_hd__o211ai_4
XFILLER_115_169 VGND VGND VPWR VPWR sky130_fd_sc_hd__fill_2
X_6171_ _1873_ _2033_ VGND VGND VPWR VPWR _2034_ sky130_fd_sc_hd__or2_1
X_5122_ _0832_ _0840_ _0839_ VGND VGND VPWR VPWR _0890_ sky130_fd_sc_hd__o21ba_1
X_5053_ net418 net321 _0813_ VGND VGND VPWR VPWR _0815_ sky130_fd_sc_hd__and3_1
XFILLER_57_429 VGND VGND VPWR VPWR sky130_fd_sc_hd__decap_4
XFILLER_38_632 VPWR VGND VPWR VGND sky130_ef_sc_hd__decap_12
X_4004_ net350 _0841_ _2018_ VGND VGND VPWR VPWR _3192_ sky130_fd_sc_hd__o21ai_1
XFILLER_65_473 VGND VGND VPWR VPWR sky130_fd_sc_hd__decap_4
XFILLER_53_602 VGND VGND VPWR VPWR sky130_fd_sc_hd__decap_8
XFILLER_1_81 VGND VGND VPWR VPWR sky130_fd_sc_hd__decap_4
XFILLER_25_304 VGND VGND VPWR VPWR sky130_fd_sc_hd__decap_6
XFILLER_52_101 VPWR VGND VPWR VGND sky130_ef_sc_hd__decap_12
XFILLER_111_27 VPWR VGND VPWR VGND sky130_ef_sc_hd__decap_12
XFILLER_80_421 VPWR VGND VPWR VGND sky130_ef_sc_hd__decap_12
XFILLER_25_337 VGND VGND VPWR VPWR sky130_fd_sc_hd__decap_6
X_5955_ _1612_ _1655_ _1797_ net113 VGND VGND VPWR VPWR _1799_ sky130_fd_sc_hd__a211o_2
XFILLER_52_167 VPWR VGND VPWR VGND sky130_ef_sc_hd__decap_12
X_4906_ net365 net211 net203 net373 VGND VGND VPWR VPWR _0665_ sky130_fd_sc_hd__a22o_1
X_5886_ _1721_ _1723_ VGND VGND VPWR VPWR _1724_ sky130_fd_sc_hd__nor2_1
XTAP_TAPCELL_ROW_23_527 VGND VPWR sky130_fd_sc_hd__tapvpwrvgnd_1
X_4837_ _0577_ _0595_ _0596_ VGND VGND VPWR VPWR _0597_ sky130_fd_sc_hd__and3_1
XTAP_TAPCELL_ROW_51_858 VGND VPWR sky130_fd_sc_hd__tapvpwrvgnd_1
XTAP_TAPCELL_ROW_51_869 VGND VPWR sky130_fd_sc_hd__tapvpwrvgnd_1
X_4768_ _0457_ _0527_ _0528_ VGND VGND VPWR VPWR _0529_ sky130_fd_sc_hd__or3_2
XFILLER_107_615 VGND VGND VPWR VPWR sky130_fd_sc_hd__fill_1
X_4699_ _0459_ _0460_ _0387_ VGND VGND VPWR VPWR _0461_ sky130_fd_sc_hd__o21ba_1
X_3719_ net377 net201 VGND VGND VPWR VPWR _2919_ sky130_fd_sc_hd__nor2_1
X_6507_ _2399_ _2400_ VGND VGND VPWR VPWR _2402_ sky130_fd_sc_hd__or2_1
XFILLER_106_147 VPWR VGND VPWR VGND sky130_ef_sc_hd__decap_12
X_6438_ _2323_ _2324_ VGND VGND VPWR VPWR _2327_ sky130_fd_sc_hd__nand2_1
XTAP_TAPCELL_ROW_95_1389 VGND VPWR sky130_fd_sc_hd__tapvpwrvgnd_1
XFILLER_88_543 VGND VGND VPWR VPWR sky130_fd_sc_hd__decap_4
X_6369_ _2242_ _2250_ VGND VGND VPWR VPWR _2251_ sky130_fd_sc_hd__xnor2_1
XFILLER_0_414 VGND VGND VPWR VPWR sky130_fd_sc_hd__decap_6
XFILLER_102_342 VPWR VGND VPWR VGND sky130_ef_sc_hd__decap_12
XFILLER_88_587 VGND VGND VPWR VPWR sky130_fd_sc_hd__fill_1
XFILLER_75_237 VPWR VGND VPWR VGND sky130_ef_sc_hd__decap_12
XFILLER_29_55 VGND VGND VPWR VPWR sky130_fd_sc_hd__fill_1
XTAP_TAPCELL_ROW_59_958 VGND VPWR sky130_fd_sc_hd__tapvpwrvgnd_1
XFILLER_29_665 VGND VGND VPWR VPWR sky130_fd_sc_hd__decap_6
XFILLER_56_484 VPWR VGND VPWR VGND sky130_ef_sc_hd__decap_12
XTAP_TAPCELL_ROW_3_285 VGND VPWR sky130_fd_sc_hd__tapvpwrvgnd_1
XFILLER_28_153 VPWR VGND VPWR VGND sky130_ef_sc_hd__decap_12
XFILLER_44_613 VPWR VGND VPWR VGND sky130_ef_sc_hd__decap_12
XFILLER_71_421 VGND VGND VPWR VPWR sky130_fd_sc_hd__fill_2
XFILLER_44_657 VPWR VGND VPWR VGND sky130_ef_sc_hd__decap_12
XFILLER_43_145 VPWR VGND VPWR VGND sky130_ef_sc_hd__decap_12
XTAP_TAPCELL_ROW_104_1496 VGND VPWR sky130_fd_sc_hd__tapvpwrvgnd_1
XFILLER_61_31 VGND VGND VPWR VPWR sky130_fd_sc_hd__decap_8
XFILLER_61_53 VGND VGND VPWR VPWR sky130_fd_sc_hd__decap_3
XFILLER_12_587 VGND VGND VPWR VPWR sky130_fd_sc_hd__fill_1
XFILLER_8_569 VPWR VGND VPWR VGND sky130_ef_sc_hd__decap_12
XFILLER_6_15 VPWR VGND VPWR VGND sky130_ef_sc_hd__decap_12
XANTENNA_8 b[29] VGND VGND VPWR VPWR sky130_fd_sc_hd__diode_2
XFILLER_113_629 VPWR VGND VPWR VGND sky130_ef_sc_hd__decap_12
XFILLER_98_329 VGND VGND VPWR VPWR sky130_fd_sc_hd__fill_2
XFILLER_112_139 VGND VGND VPWR VPWR sky130_fd_sc_hd__fill_1
XFILLER_106_681 VGND VGND VPWR VPWR sky130_fd_sc_hd__decap_8
XFILLER_79_543 VGND VGND VPWR VPWR sky130_fd_sc_hd__decap_4
XFILLER_79_532 VGND VGND VPWR VPWR sky130_fd_sc_hd__fill_1
XTAP_TAPCELL_ROW_72_1120 VGND VPWR sky130_fd_sc_hd__tapvpwrvgnd_1
XFILLER_79_576 VGND VGND VPWR VPWR sky130_fd_sc_hd__fill_1
XFILLER_79_587 VPWR VGND VPWR VGND sky130_ef_sc_hd__decap_12
XFILLER_94_557 VPWR VGND VPWR VGND sky130_ef_sc_hd__decap_12
XFILLER_47_462 VPWR VGND VPWR VGND sky130_ef_sc_hd__decap_12
XFILLER_34_112 VPWR VGND VPWR VGND sky130_ef_sc_hd__decap_12
XFILLER_96_3 VPWR VGND VPWR VGND sky130_ef_sc_hd__decap_12
XFILLER_15_370 VGND VGND VPWR VPWR sky130_fd_sc_hd__decap_4
XFILLER_34_178 VGND VGND VPWR VPWR sky130_fd_sc_hd__decap_3
X_5740_ _1429_ _1432_ _1562_ _1563_ VGND VGND VPWR VPWR _1565_ sky130_fd_sc_hd__o211ai_2
X_5671_ net429 net383 net331 net325 VGND VGND VPWR VPWR _1489_ sky130_fd_sc_hd__and4_1
X_4622_ _0368_ _0369_ _0383_ _0384_ VGND VGND VPWR VPWR _0385_ sky130_fd_sc_hd__nand4_2
XFILLER_116_412 VGND VGND VPWR VPWR sky130_fd_sc_hd__decap_8
X_4553_ _0236_ _0315_ _0316_ VGND VGND VPWR VPWR _0317_ sky130_fd_sc_hd__nand3_1
X_4484_ net287 net370 _0246_ _0247_ VGND VGND VPWR VPWR _0249_ sky130_fd_sc_hd__a22o_1
X_3504_ net285 net456 VGND VGND VPWR VPWR _1844_ sky130_fd_sc_hd__or2_1
XFILLER_116_489 VPWR VGND VPWR VGND sky130_ef_sc_hd__decap_12
X_3435_ net473 net349 VGND VGND VPWR VPWR _1092_ sky130_fd_sc_hd__and2_2
X_6223_ net258 net319 _2089_ _2090_ VGND VGND VPWR VPWR _2091_ sky130_fd_sc_hd__nand4_2
XFILLER_106_27 VGND VGND VPWR VPWR sky130_fd_sc_hd__fill_1
X_6154_ _2012_ _2013_ _2014_ net149 VGND VGND VPWR VPWR _2016_ sky130_fd_sc_hd__a31o_1
X_5105_ _0869_ _0870_ _0766_ _0769_ VGND VGND VPWR VPWR _0872_ sky130_fd_sc_hd__a211o_1
XFILLER_57_204 VGND VGND VPWR VPWR sky130_fd_sc_hd__fill_1
X_6085_ _1936_ _1937_ _1752_ VGND VGND VPWR VPWR _1940_ sky130_fd_sc_hd__a21oi_1
X_5036_ net372 net189 net344 net379 VGND VGND VPWR VPWR _0796_ sky130_fd_sc_hd__a22o_1
XTAP_TAPCELL_ROW_56_928 VGND VPWR sky130_fd_sc_hd__tapvpwrvgnd_1
XFILLER_26_613 VPWR VGND VPWR VGND sky130_ef_sc_hd__decap_12
XFILLER_38_451 VPWR VGND VPWR VGND sky130_ef_sc_hd__decap_12
XTAP_TAPCELL_ROW_0_244 VGND VPWR sky130_fd_sc_hd__tapvpwrvgnd_1
XFILLER_26_657 VPWR VGND VPWR VGND sky130_ef_sc_hd__decap_12
XTAP_TAPCELL_ROW_0_255 VGND VPWR sky130_fd_sc_hd__tapvpwrvgnd_1
XFILLER_25_167 VGND VGND VPWR VPWR sky130_fd_sc_hd__fill_1
XFILLER_80_262 VPWR VGND VPWR VGND sky130_ef_sc_hd__decap_12
X_5938_ _1777_ _1778_ _1774_ VGND VGND VPWR VPWR _1781_ sky130_fd_sc_hd__a21o_1
XFILLER_15_57 VGND VGND VPWR VPWR sky130_fd_sc_hd__decap_8
XTAP_TAPCELL_ROW_36_685 VGND VPWR sky130_fd_sc_hd__tapvpwrvgnd_1
XFILLER_40_115 VGND VGND VPWR VPWR sky130_fd_sc_hd__fill_2
XFILLER_21_373 VGND VGND VPWR VPWR sky130_fd_sc_hd__fill_1
X_5869_ _1525_ _1569_ _1704_ _1705_ VGND VGND VPWR VPWR _1706_ sky130_fd_sc_hd__a211oi_2
XTAP_TAPCELL_ROW_97_1418 VGND VPWR sky130_fd_sc_hd__tapvpwrvgnd_1
XFILLER_5_517 VPWR VGND VPWR VGND sky130_ef_sc_hd__decap_12
XTAP_TAPCELL_ROW_8_344 VGND VPWR sky130_fd_sc_hd__tapvpwrvgnd_1
Xoutput89 net89 VGND VGND VPWR VPWR return_port[20] sky130_fd_sc_hd__clkbuf_4
Xoutput78 net78 VGND VGND VPWR VPWR return_port[10] sky130_fd_sc_hd__clkbuf_4
XFILLER_103_673 VPWR VGND VPWR VGND sky130_ef_sc_hd__decap_12
XFILLER_88_395 VPWR VGND VPWR VGND sky130_ef_sc_hd__decap_12
XFILLER_48_226 VGND VGND VPWR VPWR sky130_fd_sc_hd__fill_1
XFILLER_76_557 VGND VGND VPWR VPWR sky130_fd_sc_hd__fill_2
XFILLER_91_505 VPWR VGND VPWR VGND sky130_ef_sc_hd__decap_12
XFILLER_63_218 VGND VGND VPWR VPWR sky130_fd_sc_hd__decap_6
XFILLER_63_207 VGND VGND VPWR VPWR sky130_fd_sc_hd__decap_3
XTAP_TAPCELL_ROW_106_1525 VGND VPWR sky130_fd_sc_hd__tapvpwrvgnd_1
XFILLER_91_538 VGND VGND VPWR VPWR sky130_fd_sc_hd__decap_3
XFILLER_44_421 VPWR VGND VPWR VGND sky130_ef_sc_hd__decap_12
XPHY_EDGE_ROW_113_Right_113 VGND VGND VPWR VPWR sky130_fd_sc_hd__decap_3
XFILLER_71_273 VGND VGND VPWR VPWR sky130_fd_sc_hd__decap_6
XFILLER_16_178 VPWR VGND VPWR VGND sky130_ef_sc_hd__decap_12
XFILLER_72_74 VGND VGND VPWR VPWR sky130_fd_sc_hd__fill_1
XFILLER_31_137 VPWR VGND VPWR VGND sky130_ef_sc_hd__decap_12
XFILLER_8_355 VGND VGND VPWR VPWR sky130_fd_sc_hd__decap_3
XFILLER_98_137 VGND VGND VPWR VPWR sky130_fd_sc_hd__decap_3
XFILLER_98_159 VPWR VGND VPWR VGND sky130_ef_sc_hd__decap_12
XFILLER_100_109 VPWR VGND VPWR VGND sky130_ef_sc_hd__decap_12
XFILLER_79_362 VGND VGND VPWR VPWR sky130_fd_sc_hd__decap_3
XFILLER_11_3 VPWR VGND VPWR VGND sky130_ef_sc_hd__decap_12
XFILLER_47_281 VGND VGND VPWR VPWR sky130_fd_sc_hd__decap_8
XFILLER_47_292 VPWR VGND VPWR VGND sky130_ef_sc_hd__decap_12
XFILLER_62_251 VGND VGND VPWR VPWR sky130_fd_sc_hd__fill_1
X_6841_ net442 net185 net340 net445 VGND VGND VPWR VPWR _2766_ sky130_fd_sc_hd__a22o_1
XTAP_TAPCELL_ROW_81_1219 VGND VPWR sky130_fd_sc_hd__tapvpwrvgnd_1
XTAP_TAPCELL_ROW_33_644 VGND VPWR sky130_fd_sc_hd__tapvpwrvgnd_1
X_6772_ _2622_ _2689_ VGND VGND VPWR VPWR _2690_ sky130_fd_sc_hd__xor2_1
X_3984_ net135 _3160_ _3166_ _3172_ net129 VGND VGND VPWR VPWR _3173_ sky130_fd_sc_hd__o221a_1
XTAP_TAPCELL_ROW_61_986 VGND VPWR sky130_fd_sc_hd__tapvpwrvgnd_1
XFILLER_22_159 VPWR VGND VPWR VGND sky130_ef_sc_hd__decap_12
X_5723_ net172 net168 net206 net199 VGND VGND VPWR VPWR _1546_ sky130_fd_sc_hd__nand4_2
XFILLER_31_671 VGND VGND VPWR VPWR sky130_fd_sc_hd__fill_1
X_5654_ _1467_ _1468_ VGND VGND VPWR VPWR _1470_ sky130_fd_sc_hd__xor2_1
X_4605_ net357 net386 _0366_ _0367_ VGND VGND VPWR VPWR _0368_ sky130_fd_sc_hd__a22o_1
XFILLER_7_91 VGND VGND VPWR VPWR sky130_fd_sc_hd__decap_3
X_5585_ _1269_ _1393_ VGND VGND VPWR VPWR _1395_ sky130_fd_sc_hd__nor2_1
X_4536_ _0298_ _0299_ _0297_ VGND VGND VPWR VPWR _0300_ sky130_fd_sc_hd__a21o_1
X_4467_ _0231_ _0232_ VGND VGND VPWR VPWR _0233_ sky130_fd_sc_hd__xnor2_1
XTAP_TAPCELL_ROW_92_1359 VGND VPWR sky130_fd_sc_hd__tapvpwrvgnd_1
XFILLER_104_448 VPWR VGND VPWR VGND sky130_ef_sc_hd__decap_12
X_4398_ net249 net399 _0162_ _0163_ VGND VGND VPWR VPWR _0165_ sky130_fd_sc_hd__nand4_1
X_6206_ _2070_ _2071_ VGND VGND VPWR VPWR _2072_ sky130_fd_sc_hd__nor2_1
X_3418_ net22 VGND VGND VPWR VPWR _0906_ sky130_fd_sc_hd__inv_2
XFILLER_58_513 VGND VGND VPWR VPWR sky130_fd_sc_hd__fill_2
XTAP_TAPCELL_ROW_5_314 VGND VPWR sky130_fd_sc_hd__tapvpwrvgnd_1
X_6137_ _1992_ _1994_ _1835_ _1839_ VGND VGND VPWR VPWR _1998_ sky130_fd_sc_hd__o211a_1
XFILLER_100_643 VGND VGND VPWR VPWR sky130_fd_sc_hd__fill_1
XFILLER_58_557 VGND VGND VPWR VPWR sky130_fd_sc_hd__decap_8
XFILLER_93_18 VPWR VGND VPWR VGND sky130_ef_sc_hd__decap_12
XFILLER_85_376 VGND VGND VPWR VPWR sky130_fd_sc_hd__decap_4
XFILLER_73_505 VGND VGND VPWR VPWR sky130_fd_sc_hd__fill_1
X_6068_ net429 net382 net314 net305 VGND VGND VPWR VPWR _1922_ sky130_fd_sc_hd__and4_1
X_5019_ _0681_ _0777_ _0778_ VGND VGND VPWR VPWR _0779_ sky130_fd_sc_hd__nor3_1
XFILLER_26_421 VGND VGND VPWR VPWR sky130_fd_sc_hd__decap_8
XFILLER_38_270 VPWR VGND VPWR VGND sky130_ef_sc_hd__decap_12
XFILLER_13_137 VGND VGND VPWR VPWR sky130_fd_sc_hd__fill_2
XFILLER_41_446 VGND VGND VPWR VPWR sky130_fd_sc_hd__fill_2
XTAP_TAPCELL_ROW_101_1466 VGND VPWR sky130_fd_sc_hd__tapvpwrvgnd_1
XFILLER_21_181 VGND VGND VPWR VPWR sky130_fd_sc_hd__fill_1
XFILLER_107_242 VGND VGND VPWR VPWR sky130_fd_sc_hd__fill_1
XFILLER_3_27 VPWR VGND VPWR VGND sky130_ef_sc_hd__decap_12
XFILLER_1_553 VGND VGND VPWR VPWR sky130_fd_sc_hd__decap_6
XTAP_TAPCELL_ROW_112_1595 VGND VPWR sky130_fd_sc_hd__tapvpwrvgnd_1
XFILLER_110_429 VGND VGND VPWR VPWR sky130_fd_sc_hd__decap_6
XFILLER_110_407 VPWR VGND VPWR VGND sky130_ef_sc_hd__decap_12
XFILLER_89_671 VGND VGND VPWR VPWR sky130_fd_sc_hd__fill_1
XFILLER_103_492 VGND VGND VPWR VPWR sky130_fd_sc_hd__decap_6
XFILLER_76_321 VPWR VGND VPWR VGND sky130_ef_sc_hd__decap_12
XFILLER_1_597 VPWR VGND VPWR VGND sky130_ef_sc_hd__decap_12
XFILLER_76_365 VPWR VGND VPWR VGND sky130_ef_sc_hd__decap_12
XFILLER_91_335 VGND VGND VPWR VPWR sky130_fd_sc_hd__fill_1
XFILLER_83_51 VGND VGND VPWR VPWR sky130_fd_sc_hd__decap_4
XTAP_TAPCELL_ROW_67_1052 VGND VPWR sky130_fd_sc_hd__tapvpwrvgnd_1
XFILLER_17_443 VGND VGND VPWR VPWR sky130_fd_sc_hd__decap_4
XFILLER_17_476 VPWR VGND VPWR VGND sky130_ef_sc_hd__decap_12
XFILLER_44_284 VPWR VGND VPWR VGND sky130_ef_sc_hd__decap_12
XFILLER_13_671 VGND VGND VPWR VPWR sky130_fd_sc_hd__fill_1
XFILLER_32_468 VGND VGND VPWR VPWR sky130_fd_sc_hd__decap_8
XFILLER_9_653 VPWR VGND VPWR VGND sky130_ef_sc_hd__decap_12
XTAP_TAPCELL_ROW_30_614 VGND VPWR sky130_fd_sc_hd__tapvpwrvgnd_1
XFILLER_8_141 VGND VGND VPWR VPWR sky130_fd_sc_hd__decap_4
XTAP_TAPCELL_ROW_10_371 VGND VPWR sky130_fd_sc_hd__tapvpwrvgnd_1
X_5370_ net376 net368 net332 net326 VGND VGND VPWR VPWR _1161_ sky130_fd_sc_hd__nand4_1
X_4321_ _0069_ _0087_ net149 VGND VGND VPWR VPWR _0091_ sky130_fd_sc_hd__a21oi_1
XTAP_TAPCELL_ROW_78_1192 VGND VPWR sky130_fd_sc_hd__tapvpwrvgnd_1
XFILLER_99_468 VPWR VGND VPWR VGND sky130_ef_sc_hd__decap_12
X_4252_ _0021_ _0022_ _0027_ VGND VGND VPWR VPWR _alu_i0.Datapath_i.fu_alu_33673_33851.out1\[30\]
+ sky130_fd_sc_hd__a21o_1
XFILLER_113_267 VPWR VGND VPWR VGND sky130_ef_sc_hd__decap_12
XFILLER_86_129 VGND VGND VPWR VPWR sky130_fd_sc_hd__decap_6
XFILLER_95_641 VPWR VGND VPWR VGND sky130_ef_sc_hd__decap_12
XFILLER_79_192 VGND VGND VPWR VPWR sky130_fd_sc_hd__fill_2
X_4183_ _3362_ _3325_ net278 VGND VGND VPWR VPWR _3363_ sky130_fd_sc_hd__mux2_1
XFILLER_95_685 VGND VGND VPWR VPWR sky130_fd_sc_hd__decap_6
XFILLER_55_505 VPWR VGND VPWR VGND sky130_ef_sc_hd__decap_12
XTAP_TAPCELL_ROW_38_703 VGND VPWR sky130_fd_sc_hd__tapvpwrvgnd_1
XFILLER_103_39 VPWR VGND VPWR VGND sky130_ef_sc_hd__decap_12
XFILLER_82_324 VPWR VGND VPWR VGND sky130_ef_sc_hd__decap_12
XFILLER_27_229 VGND VGND VPWR VPWR sky130_fd_sc_hd__decap_4
XFILLER_82_357 VGND VGND VPWR VPWR sky130_fd_sc_hd__decap_6
XFILLER_63_593 VGND VGND VPWR VPWR sky130_fd_sc_hd__decap_4
X_6824_ _2744_ _2746_ VGND VGND VPWR VPWR _2747_ sky130_fd_sc_hd__xnor2_1
XTAP_TAPCELL_ROW_18_471 VGND VPWR sky130_fd_sc_hd__tapvpwrvgnd_1
XFILLER_23_457 VGND VGND VPWR VPWR sky130_fd_sc_hd__decap_8
X_3967_ net155 _2975_ _3156_ net121 VGND VGND VPWR VPWR _3157_ sky130_fd_sc_hd__o211a_1
X_6755_ _2617_ _2637_ _2636_ VGND VGND VPWR VPWR _2671_ sky130_fd_sc_hd__a21bo_1
X_5706_ net223 net462 net450 net235 VGND VGND VPWR VPWR _1527_ sky130_fd_sc_hd__a22o_1
X_3898_ net129 _3075_ _3089_ net122 VGND VGND VPWR VPWR _3091_ sky130_fd_sc_hd__a2bb2o_1
X_6686_ _2382_ _2426_ VGND VGND VPWR VPWR _2596_ sky130_fd_sc_hd__nand2_1
X_5637_ _1326_ _1328_ _1449_ _1451_ VGND VGND VPWR VPWR _1453_ sky130_fd_sc_hd__a211oi_1
X_5568_ _1373_ _1374_ _1309_ VGND VGND VPWR VPWR _1377_ sky130_fd_sc_hd__a21o_1
X_4519_ _0230_ _0232_ _0229_ VGND VGND VPWR VPWR _0284_ sky130_fd_sc_hd__a21o_1
XFILLER_88_29 VGND VGND VPWR VPWR sky130_fd_sc_hd__decap_8
X_5499_ _1300_ _1301_ VGND VGND VPWR VPWR _1302_ sky130_fd_sc_hd__and2b_1
XFILLER_58_321 VPWR VGND VPWR VGND sky130_ef_sc_hd__decap_12
XFILLER_58_365 VPWR VGND VPWR VGND sky130_ef_sc_hd__decap_12
XFILLER_37_55 VGND VGND VPWR VPWR sky130_fd_sc_hd__fill_1
XFILLER_26_240 VPWR VGND VPWR VGND sky130_ef_sc_hd__decap_12
XFILLER_14_413 VGND VGND VPWR VPWR sky130_fd_sc_hd__fill_1
XFILLER_81_390 VGND VGND VPWR VPWR sky130_fd_sc_hd__fill_2
XFILLER_54_593 VGND VGND VPWR VPWR sky130_fd_sc_hd__fill_1
XFILLER_26_284 VGND VGND VPWR VPWR sky130_fd_sc_hd__decap_8
XFILLER_6_601 VPWR VGND VPWR VGND sky130_ef_sc_hd__decap_12
XFILLER_6_645 VPWR VGND VPWR VGND sky130_ef_sc_hd__decap_12
XFILLER_5_111 VGND VGND VPWR VPWR sky130_fd_sc_hd__fill_1
XTAP_TAPCELL_ROW_114_1624 VGND VPWR sky130_fd_sc_hd__tapvpwrvgnd_1
XFILLER_6_689 VGND VGND VPWR VPWR sky130_fd_sc_hd__decap_3
XFILLER_5_199 VGND VGND VPWR VPWR sky130_fd_sc_hd__decap_3
XFILLER_110_215 VGND VGND VPWR VPWR sky130_fd_sc_hd__fill_1
XFILLER_96_427 VPWR VGND VPWR VGND sky130_ef_sc_hd__decap_12
XFILLER_1_350 VGND VGND VPWR VPWR sky130_fd_sc_hd__decap_3
XFILLER_110_226 VPWR VGND VPWR VGND sky130_ef_sc_hd__decap_12
XFILLER_77_641 VPWR VGND VPWR VGND sky130_ef_sc_hd__decap_12
XFILLER_37_505 VGND VGND VPWR VPWR sky130_fd_sc_hd__fill_1
XFILLER_77_685 VGND VGND VPWR VPWR sky130_fd_sc_hd__decap_6
XFILLER_37_549 VGND VGND VPWR VPWR sky130_fd_sc_hd__fill_1
XFILLER_94_83 VGND VGND VPWR VPWR sky130_fd_sc_hd__fill_1
XFILLER_91_143 VPWR VGND VPWR VGND sky130_ef_sc_hd__decap_12
XFILLER_64_357 VGND VGND VPWR VPWR sky130_fd_sc_hd__decap_6
X_4870_ _0625_ _0628_ VGND VGND VPWR VPWR _0629_ sky130_fd_sc_hd__xnor2_1
X_3821_ net385 net431 net350 VGND VGND VPWR VPWR _3017_ sky130_fd_sc_hd__mux2_1
XTAP_TAPCELL_ROW_15_430 VGND VPWR sky130_fd_sc_hd__tapvpwrvgnd_1
XFILLER_32_265 VGND VGND VPWR VPWR sky130_fd_sc_hd__decap_4
XFILLER_20_416 VGND VGND VPWR VPWR sky130_fd_sc_hd__decap_4
XFILLER_32_276 VGND VGND VPWR VPWR sky130_fd_sc_hd__fill_1
X_6540_ _2437_ _2436_ VGND VGND VPWR VPWR _2438_ sky130_fd_sc_hd__nand2b_1
XTAP_TAPCELL_ROW_43_772 VGND VPWR sky130_fd_sc_hd__tapvpwrvgnd_1
X_3752_ _2945_ _2950_ VGND VGND VPWR VPWR _2951_ sky130_fd_sc_hd__xnor2_1
XFILLER_9_461 VGND VGND VPWR VPWR sky130_fd_sc_hd__decap_8
X_3683_ _2062_ _2357_ net159 VGND VGND VPWR VPWR _2885_ sky130_fd_sc_hd__mux2_1
X_6471_ net310 net301 VGND VGND VPWR VPWR _2362_ sky130_fd_sc_hd__nand2_1
X_5422_ net466 _1216_ _1215_ VGND VGND VPWR VPWR _1217_ sky130_fd_sc_hd__a21bo_1
XFILLER_99_210 VGND VGND VPWR VPWR sky130_fd_sc_hd__fill_1
X_5353_ _1030_ _1033_ _1140_ _1141_ VGND VGND VPWR VPWR _1142_ sky130_fd_sc_hd__a211oi_2
X_4304_ net471 net225 net454 net238 VGND VGND VPWR VPWR _0074_ sky130_fd_sc_hd__a22o_1
XFILLER_99_221 VGND VGND VPWR VPWR sky130_fd_sc_hd__decap_3
XFILLER_114_587 VGND VGND VPWR VPWR sky130_fd_sc_hd__fill_1
X_5284_ _0937_ _1066_ VGND VGND VPWR VPWR _1067_ sky130_fd_sc_hd__nand2_1
XFILLER_87_449 VPWR VGND VPWR VGND sky130_ef_sc_hd__decap_12
XFILLER_68_641 VGND VGND VPWR VPWR sky130_fd_sc_hd__decap_3
X_4235_ _3391_ _3394_ _3392_ VGND VGND VPWR VPWR _0011_ sky130_fd_sc_hd__a21oi_1
XFILLER_114_27 VGND VGND VPWR VPWR sky130_fd_sc_hd__fill_1
XFILLER_67_151 VGND VGND VPWR VPWR sky130_fd_sc_hd__fill_2
X_4166_ net157 _3176_ _3346_ net120 VGND VGND VPWR VPWR _3347_ sky130_fd_sc_hd__o211a_1
XFILLER_68_685 VGND VGND VPWR VPWR sky130_fd_sc_hd__fill_1
XFILLER_67_162 VGND VGND VPWR VPWR sky130_fd_sc_hd__decap_6
XFILLER_55_302 VPWR VGND VPWR VGND sky130_ef_sc_hd__decap_12
XFILLER_28_527 VGND VGND VPWR VPWR sky130_fd_sc_hd__decap_4
X_4097_ net230 _2938_ VGND VGND VPWR VPWR _3281_ sky130_fd_sc_hd__and2_1
XFILLER_11_405 VGND VGND VPWR VPWR sky130_fd_sc_hd__decap_3
X_6807_ _2726_ _2727_ VGND VGND VPWR VPWR _2729_ sky130_fd_sc_hd__xnor2_1
X_4999_ _0755_ _0756_ _0749_ VGND VGND VPWR VPWR _0757_ sky130_fd_sc_hd__a21o_1
XFILLER_51_585 VGND VGND VPWR VPWR sky130_fd_sc_hd__decap_3
X_6738_ _2481_ _2483_ _2650_ VGND VGND VPWR VPWR _2654_ sky130_fd_sc_hd__or3_1
XFILLER_23_57 VGND VGND VPWR VPWR sky130_fd_sc_hd__decap_6
XFILLER_109_337 VPWR VGND VPWR VGND sky130_ef_sc_hd__decap_12
X_6669_ _0830_ _0950_ _2577_ _2576_ VGND VGND VPWR VPWR _2578_ sky130_fd_sc_hd__o31a_1
XFILLER_99_39 VPWR VGND VPWR VGND sky130_ef_sc_hd__decap_12
XTAP_TAPCELL_ROW_21_499 VGND VPWR sky130_fd_sc_hd__tapvpwrvgnd_1
XFILLER_3_615 VGND VGND VPWR VPWR sky130_fd_sc_hd__fill_1
XFILLER_59_641 VPWR VGND VPWR VGND sky130_ef_sc_hd__decap_12
Xfanout440 net441 VGND VGND VPWR VPWR net440 sky130_fd_sc_hd__buf_2
XFILLER_93_408 VGND VGND VPWR VPWR sky130_fd_sc_hd__fill_1
Xfanout473 net475 VGND VGND VPWR VPWR net473 sky130_fd_sc_hd__buf_2
Xfanout451 net452 VGND VGND VPWR VPWR net451 sky130_fd_sc_hd__clkbuf_4
XFILLER_19_505 VPWR VGND VPWR VGND sky130_ef_sc_hd__decap_12
Xfanout462 net11 VGND VGND VPWR VPWR net462 sky130_fd_sc_hd__clkbuf_4
XFILLER_74_622 VPWR VGND VPWR VGND sky130_ef_sc_hd__decap_12
XFILLER_59_685 VGND VGND VPWR VPWR sky130_fd_sc_hd__fill_1
XFILLER_73_165 VGND VGND VPWR VPWR sky130_fd_sc_hd__decap_3
XFILLER_27_571 VGND VGND VPWR VPWR sky130_fd_sc_hd__fill_1
XTAP_TAPCELL_ROW_64_1022 VGND VPWR sky130_fd_sc_hd__tapvpwrvgnd_1
XFILLER_61_349 VPWR VGND VPWR VGND sky130_ef_sc_hd__decap_12
XTAP_TAPCELL_ROW_29_599 VGND VPWR sky130_fd_sc_hd__tapvpwrvgnd_1
XFILLER_9_15 VPWR VGND VPWR VGND sky130_ef_sc_hd__decap_12
XTAP_TAPCELL_ROW_12_400 VGND VPWR sky130_fd_sc_hd__tapvpwrvgnd_1
XFILLER_42_596 VPWR VGND VPWR VGND sky130_ef_sc_hd__decap_12
XFILLER_80_74 VGND VGND VPWR VPWR sky130_fd_sc_hd__decap_8
XTAP_TAPCELL_ROW_40_731 VGND VPWR sky130_fd_sc_hd__tapvpwrvgnd_1
XFILLER_80_85 VGND VGND VPWR VPWR sky130_fd_sc_hd__decap_4
XFILLER_13_90 VPWR VGND VPWR VGND sky130_ef_sc_hd__decap_12
XFILLER_108_370 VPWR VGND VPWR VGND sky130_ef_sc_hd__decap_12
XTAP_TAPCELL_ROW_75_1151 VGND VPWR sky130_fd_sc_hd__tapvpwrvgnd_1
XFILLER_69_405 VGND VGND VPWR VPWR sky130_fd_sc_hd__fill_1
XFILLER_2_681 VGND VGND VPWR VPWR sky130_fd_sc_hd__decap_8
XFILLER_84_419 VGND VGND VPWR VPWR sky130_fd_sc_hd__fill_1
X_4020_ net142 _3199_ net135 VGND VGND VPWR VPWR _3207_ sky130_fd_sc_hd__o21ai_1
XFILLER_49_184 VGND VGND VPWR VPWR sky130_fd_sc_hd__decap_4
XFILLER_92_441 VGND VGND VPWR VPWR sky130_fd_sc_hd__decap_4
XFILLER_37_335 VGND VGND VPWR VPWR sky130_fd_sc_hd__fill_1
XTAP_TAPCELL_ROW_48_831 VGND VPWR sky130_fd_sc_hd__tapvpwrvgnd_1
X_5971_ _1408_ _1815_ VGND VGND VPWR VPWR _1817_ sky130_fd_sc_hd__nor2_1
X_4922_ _0595_ _0598_ _0678_ _0680_ VGND VGND VPWR VPWR _0681_ sky130_fd_sc_hd__a211o_1
XTAP_TAPCELL_ROW_86_1280 VGND VPWR sky130_fd_sc_hd__tapvpwrvgnd_1
XFILLER_80_669 VPWR VGND VPWR VGND sky130_ef_sc_hd__decap_12
XFILLER_80_636 VGND VGND VPWR VPWR sky130_fd_sc_hd__decap_8
XFILLER_33_530 VPWR VGND VPWR VGND sky130_ef_sc_hd__decap_12
XFILLER_33_552 VGND VGND VPWR VPWR sky130_fd_sc_hd__fill_1
X_4853_ _0533_ _0535_ _0611_ _0612_ VGND VGND VPWR VPWR _0613_ sky130_fd_sc_hd__o211a_1
XFILLER_100_29 VPWR VGND VPWR VGND sky130_ef_sc_hd__decap_12
X_4784_ net393 net195 VGND VGND VPWR VPWR _0544_ sky130_fd_sc_hd__nand2_1
X_3804_ _2553_ _2959_ _2995_ _3000_ VGND VGND VPWR VPWR _alu_i0.Datapath_i.fu_alu_33673_33851.out1\[10\]
+ sky130_fd_sc_hd__a211o_1
X_3735_ _1266_ _2934_ VGND VGND VPWR VPWR _2935_ sky130_fd_sc_hd__and2_1
X_6523_ _2402_ _2417_ VGND VGND VPWR VPWR _2419_ sky130_fd_sc_hd__nand2_1
XFILLER_109_27 VPWR VGND VPWR VGND sky130_ef_sc_hd__decap_12
X_6454_ _2183_ _2187_ VGND VGND VPWR VPWR _2343_ sky130_fd_sc_hd__nor2_1
XFILLER_106_307 VGND VGND VPWR VPWR sky130_fd_sc_hd__fill_1
X_3666_ _2857_ _2868_ VGND VGND VPWR VPWR _alu_i0.Datapath_i.fu_alu_33673_33851.out1\[4\]
+ sky130_fd_sc_hd__or2_1
X_5405_ _1034_ _1036_ _1197_ _1198_ VGND VGND VPWR VPWR _1199_ sky130_fd_sc_hd__o211ai_4
X_3597_ _2739_ _2794_ net127 VGND VGND VPWR VPWR _2802_ sky130_fd_sc_hd__o21ai_1
X_6385_ net245 net435 VGND VGND VPWR VPWR _2268_ sky130_fd_sc_hd__nand2_1
X_5336_ net177 net213 _1121_ _1122_ VGND VGND VPWR VPWR _1123_ sky130_fd_sc_hd__a22o_1
XFILLER_0_629 VPWR VGND VPWR VGND sky130_ef_sc_hd__decap_12
XFILLER_114_373 VGND VGND VPWR VPWR sky130_fd_sc_hd__fill_1
XFILLER_87_213 VGND VGND VPWR VPWR sky130_fd_sc_hd__decap_8
X_5267_ net372 net337 VGND VGND VPWR VPWR _1049_ sky130_fd_sc_hd__and2_1
X_4218_ net125 _3395_ net144 VGND VGND VPWR VPWR _3396_ sky130_fd_sc_hd__a21o_1
X_5198_ _0938_ _0971_ VGND VGND VPWR VPWR _0974_ sky130_fd_sc_hd__xnor2_1
XFILLER_68_460 VPWR VGND VPWR VGND sky130_ef_sc_hd__decap_12
X_4149_ _3330_ _3324_ VGND VGND VPWR VPWR _alu_i0.Datapath_i.fu_alu_33673_33851.out1\[25\]
+ sky130_fd_sc_hd__nand2b_1
XFILLER_71_603 VPWR VGND VPWR VGND sky130_ef_sc_hd__decap_12
XFILLER_71_658 VPWR VGND VPWR VGND sky130_ef_sc_hd__decap_12
XFILLER_43_349 VPWR VGND VPWR VGND sky130_ef_sc_hd__decap_12
XTAP_TAPCELL_ROW_26_558 VGND VPWR sky130_fd_sc_hd__tapvpwrvgnd_1
XTAP_TAPCELL_ROW_26_569 VGND VPWR sky130_fd_sc_hd__tapvpwrvgnd_1
XFILLER_11_202 VPWR VGND VPWR VGND sky130_ef_sc_hd__decap_12
XFILLER_24_585 VGND VGND VPWR VPWR sky130_fd_sc_hd__decap_3
XFILLER_7_239 VPWR VGND VPWR VGND sky130_ef_sc_hd__decap_12
XFILLER_7_217 VGND VGND VPWR VPWR sky130_fd_sc_hd__decap_3
XFILLER_109_134 VPWR VGND VPWR VGND sky130_ef_sc_hd__decap_12
XFILLER_50_99 VPWR VGND VPWR VGND sky130_ef_sc_hd__decap_12
XFILLER_105_373 VGND VGND VPWR VPWR sky130_fd_sc_hd__fill_1
XFILLER_66_419 VGND VGND VPWR VPWR sky130_fd_sc_hd__fill_1
XFILLER_115_81 VPWR VGND VPWR VGND sky130_ef_sc_hd__decap_12
Xfanout281 net44 VGND VGND VPWR VPWR net281 sky130_fd_sc_hd__buf_2
XTAP_TAPCELL_ROW_70_1092 VGND VPWR sky130_fd_sc_hd__tapvpwrvgnd_1
XFILLER_59_482 VGND VGND VPWR VPWR sky130_fd_sc_hd__decap_6
Xfanout292 net293 VGND VGND VPWR VPWR net292 sky130_fd_sc_hd__buf_2
Xfanout270 net47 VGND VGND VPWR VPWR net270 sky130_fd_sc_hd__clkbuf_4
XTAP_TAPCELL_ROW_109_1556 VGND VPWR sky130_fd_sc_hd__tapvpwrvgnd_1
XFILLER_34_316 VPWR VGND VPWR VGND sky130_ef_sc_hd__decap_12
XFILLER_74_496 VGND VGND VPWR VPWR sky130_fd_sc_hd__decap_8
XFILLER_62_636 VGND VGND VPWR VPWR sky130_fd_sc_hd__decap_8
XFILLER_62_669 VPWR VGND VPWR VGND sky130_ef_sc_hd__decap_12
XFILLER_15_541 VGND VGND VPWR VPWR sky130_fd_sc_hd__decap_8
XFILLER_15_585 VPWR VGND VPWR VGND sky130_ef_sc_hd__decap_12
X_3520_ net352 net466 VGND VGND VPWR VPWR _2018_ sky130_fd_sc_hd__nand2_2
XFILLER_115_137 VPWR VGND VPWR VGND sky130_ef_sc_hd__decap_12
X_3451_ _0808_ _1255_ VGND VGND VPWR VPWR _1266_ sky130_fd_sc_hd__nor2_2
X_6170_ _2031_ _2032_ VGND VGND VPWR VPWR _2033_ sky130_fd_sc_hd__or2_1
XFILLER_111_310 VGND VGND VPWR VPWR sky130_fd_sc_hd__decap_3
X_5121_ _alu_i0.Datapath_i.reg_0.reg_out1\[17\] _0889_ net146 VGND VGND VPWR VPWR
+ net85 sky130_fd_sc_hd__mux2_1
XFILLER_111_354 VGND VGND VPWR VPWR sky130_fd_sc_hd__fill_2
X_5052_ net418 net321 VGND VGND VPWR VPWR _0814_ sky130_fd_sc_hd__nand2_1
XFILLER_65_430 VGND VGND VPWR VPWR sky130_fd_sc_hd__fill_1
X_4003_ net129 _3185_ _3189_ _3190_ VGND VGND VPWR VPWR _3191_ sky130_fd_sc_hd__o22a_1
XFILLER_92_260 VPWR VGND VPWR VGND sky130_ef_sc_hd__decap_12
XFILLER_80_433 VGND VGND VPWR VPWR sky130_fd_sc_hd__fill_1
XFILLER_52_113 VGND VGND VPWR VPWR sky130_fd_sc_hd__fill_1
XFILLER_111_39 VPWR VGND VPWR VGND sky130_ef_sc_hd__decap_12
XFILLER_80_477 VGND VGND VPWR VPWR sky130_fd_sc_hd__decap_4
X_5954_ _1756_ _1758_ _1794_ _1796_ VGND VGND VPWR VPWR _1798_ sky130_fd_sc_hd__nor4_1
X_4905_ net373 net365 net211 net203 VGND VGND VPWR VPWR _0664_ sky130_fd_sc_hd__nand4_2
X_5885_ _1210_ _1211_ _1456_ _1722_ VGND VGND VPWR VPWR _1723_ sky130_fd_sc_hd__o31a_1
XFILLER_61_691 VGND VGND VPWR VPWR sky130_fd_sc_hd__fill_1
XTAP_TAPCELL_ROW_23_528 VGND VPWR sky130_fd_sc_hd__tapvpwrvgnd_1
XFILLER_52_179 VPWR VGND VPWR VGND sky130_ef_sc_hd__decap_12
X_4836_ _0592_ _0594_ _0516_ _0518_ VGND VGND VPWR VPWR _0596_ sky130_fd_sc_hd__o211ai_2
XFILLER_21_555 VGND VGND VPWR VPWR sky130_fd_sc_hd__decap_4
XFILLER_33_393 VPWR VGND VPWR VGND sky130_ef_sc_hd__decap_12
XTAP_TAPCELL_ROW_51_859 VGND VPWR sky130_fd_sc_hd__tapvpwrvgnd_1
XFILLER_21_577 VPWR VGND VPWR VGND sky130_ef_sc_hd__decap_12
X_4767_ _0525_ _0526_ _0488_ VGND VGND VPWR VPWR _0528_ sky130_fd_sc_hd__o21a_1
X_6506_ _2389_ _2398_ VGND VGND VPWR VPWR _2400_ sky130_fd_sc_hd__nor2_1
X_4698_ _0457_ _0458_ _0390_ VGND VGND VPWR VPWR _0460_ sky130_fd_sc_hd__a21oi_1
X_3718_ net377 net201 VGND VGND VPWR VPWR _2918_ sky130_fd_sc_hd__and2_1
XFILLER_4_209 VPWR VGND VPWR VGND sky130_ef_sc_hd__decap_12
X_3649_ _2806_ _2811_ _2845_ _2851_ _1887_ VGND VGND VPWR VPWR _2852_ sky130_fd_sc_hd__a311o_1
X_6437_ _2323_ _2324_ VGND VGND VPWR VPWR _2326_ sky130_fd_sc_hd__or2_1
XFILLER_115_671 VGND VGND VPWR VPWR sky130_fd_sc_hd__fill_1
X_6368_ _2247_ _2249_ VGND VGND VPWR VPWR _2250_ sky130_fd_sc_hd__nor2_1
XFILLER_96_29 VPWR VGND VPWR VGND sky130_ef_sc_hd__decap_12
X_5319_ net237 net224 net173 VGND VGND VPWR VPWR _1105_ sky130_fd_sc_hd__and3_1
XFILLER_102_354 VGND VGND VPWR VPWR sky130_fd_sc_hd__decap_8
XFILLER_88_555 VPWR VGND VPWR VGND sky130_ef_sc_hd__decap_12
X_6299_ net468 net451 net253 net53 VGND VGND VPWR VPWR _2174_ sky130_fd_sc_hd__and4_1
XFILLER_102_365 VPWR VGND VPWR VGND sky130_ef_sc_hd__decap_12
XFILLER_48_419 VGND VGND VPWR VPWR sky130_fd_sc_hd__fill_1
XFILLER_75_249 VPWR VGND VPWR VGND sky130_ef_sc_hd__decap_12
XTAP_TAPCELL_ROW_59_959 VGND VPWR sky130_fd_sc_hd__tapvpwrvgnd_1
XFILLER_28_121 VPWR VGND VPWR VGND sky130_ef_sc_hd__decap_12
XTAP_TAPCELL_ROW_3_286 VGND VPWR sky130_fd_sc_hd__tapvpwrvgnd_1
XFILLER_28_165 VPWR VGND VPWR VGND sky130_ef_sc_hd__decap_12
XFILLER_56_496 VGND VGND VPWR VPWR sky130_fd_sc_hd__fill_1
XFILLER_43_113 VGND VGND VPWR VPWR sky130_fd_sc_hd__decap_3
XFILLER_44_625 VPWR VGND VPWR VGND sky130_ef_sc_hd__decap_12
XFILLER_45_55 VGND VGND VPWR VPWR sky130_fd_sc_hd__fill_1
XFILLER_43_157 VGND VGND VPWR VPWR sky130_fd_sc_hd__decap_8
XFILLER_44_669 VPWR VGND VPWR VGND sky130_ef_sc_hd__decap_12
XFILLER_45_99 VGND VGND VPWR VPWR sky130_fd_sc_hd__decap_6
XFILLER_12_511 VPWR VGND VPWR VGND sky130_ef_sc_hd__decap_12
XTAP_TAPCELL_ROW_104_1497 VGND VPWR sky130_fd_sc_hd__tapvpwrvgnd_1
XFILLER_101_94 VPWR VGND VPWR VGND sky130_ef_sc_hd__decap_12
XFILLER_12_555 VPWR VGND VPWR VGND sky130_ef_sc_hd__decap_12
XFILLER_12_533 VGND VGND VPWR VPWR sky130_fd_sc_hd__fill_1
XANTENNA_9 b[31] VGND VGND VPWR VPWR sky130_fd_sc_hd__diode_2
XFILLER_6_27 VGND VGND VPWR VPWR sky130_fd_sc_hd__fill_1
XTAP_TAPCELL_ROW_72_1110 VGND VPWR sky130_fd_sc_hd__tapvpwrvgnd_1
XTAP_TAPCELL_ROW_72_1121 VGND VPWR sky130_fd_sc_hd__tapvpwrvgnd_1
XFILLER_3_264 VGND VGND VPWR VPWR sky130_fd_sc_hd__decap_8
XFILLER_79_555 VGND VGND VPWR VPWR sky130_fd_sc_hd__decap_4
XFILLER_94_514 VPWR VGND VPWR VGND sky130_ef_sc_hd__decap_12
XFILLER_94_569 VPWR VGND VPWR VGND sky130_ef_sc_hd__decap_12
XFILLER_19_121 VGND VGND VPWR VPWR sky130_fd_sc_hd__fill_2
XFILLER_35_614 VGND VGND VPWR VPWR sky130_fd_sc_hd__fill_2
XFILLER_47_474 VPWR VGND VPWR VGND sky130_ef_sc_hd__decap_12
XFILLER_74_271 VGND VGND VPWR VPWR sky130_fd_sc_hd__decap_4
XFILLER_19_176 VGND VGND VPWR VPWR sky130_fd_sc_hd__decap_8
XFILLER_34_124 VPWR VGND VPWR VGND sky130_ef_sc_hd__decap_12
XTAP_TAPCELL_ROW_83_1250 VGND VPWR sky130_fd_sc_hd__tapvpwrvgnd_1
XFILLER_62_477 VPWR VGND VPWR VGND sky130_ef_sc_hd__decap_12
XFILLER_15_393 VPWR VGND VPWR VGND sky130_ef_sc_hd__decap_12
X_5670_ _1486_ _1487_ VGND VGND VPWR VPWR _1488_ sky130_fd_sc_hd__xnor2_1
XFILLER_43_691 VGND VGND VPWR VPWR sky130_fd_sc_hd__fill_1
X_4621_ _0261_ _0320_ _0381_ _0382_ VGND VGND VPWR VPWR _0384_ sky130_fd_sc_hd__a2bb2o_1
X_4552_ _2869_ _0313_ _0314_ VGND VGND VPWR VPWR _0316_ sky130_fd_sc_hd__nand3_1
XFILLER_116_435 VPWR VGND VPWR VGND sky130_ef_sc_hd__decap_12
X_4483_ net287 net370 _0246_ _0247_ VGND VGND VPWR VPWR _0248_ sky130_fd_sc_hd__nand4_1
X_3503_ net120 _1626_ _1823_ _1233_ VGND VGND VPWR VPWR _alu_i0.Datapath_i.fu_alu_33673_33851.out1\[0\]
+ sky130_fd_sc_hd__a211o_1
X_3434_ net473 net349 net137 VGND VGND VPWR VPWR _1081_ sky130_fd_sc_hd__o21a_1
X_6222_ net310 net314 net305 net384 VGND VGND VPWR VPWR _2090_ sky130_fd_sc_hd__a22o_1
XFILLER_97_341 VGND VGND VPWR VPWR sky130_fd_sc_hd__fill_1
X_6153_ _2013_ _2014_ _2012_ VGND VGND VPWR VPWR _2015_ sky130_fd_sc_hd__a21oi_1
XFILLER_111_140 VGND VGND VPWR VPWR sky130_fd_sc_hd__decap_4
X_5104_ _0766_ _0769_ _0869_ _0870_ VGND VGND VPWR VPWR _0871_ sky130_fd_sc_hd__o211ai_2
X_6084_ _1752_ _1936_ _1937_ VGND VGND VPWR VPWR _1939_ sky130_fd_sc_hd__nand3_1
X_5035_ net379 net372 net189 net344 VGND VGND VPWR VPWR _0795_ sky130_fd_sc_hd__and4_1
XTAP_TAPCELL_ROW_56_929 VGND VPWR sky130_fd_sc_hd__tapvpwrvgnd_1
XTAP_TAPCELL_ROW_56_918 VGND VPWR sky130_fd_sc_hd__tapvpwrvgnd_1
XFILLER_38_463 VPWR VGND VPWR VGND sky130_ef_sc_hd__decap_12
XFILLER_65_260 VGND VGND VPWR VPWR sky130_fd_sc_hd__fill_1
XTAP_TAPCELL_ROW_0_234 VGND VPWR sky130_fd_sc_hd__tapvpwrvgnd_1
XTAP_TAPCELL_ROW_0_245 VGND VPWR sky130_fd_sc_hd__tapvpwrvgnd_1
XFILLER_25_102 VGND VGND VPWR VPWR sky130_fd_sc_hd__decap_8
XFILLER_25_113 VGND VGND VPWR VPWR sky130_fd_sc_hd__decap_8
XFILLER_26_625 VPWR VGND VPWR VGND sky130_ef_sc_hd__decap_12
XFILLER_38_485 VPWR VGND VPWR VGND sky130_ef_sc_hd__decap_12
XFILLER_80_241 VGND VGND VPWR VPWR sky130_fd_sc_hd__decap_6
XFILLER_53_455 VGND VGND VPWR VPWR sky130_fd_sc_hd__decap_8
XTAP_TAPCELL_ROW_0_256 VGND VPWR sky130_fd_sc_hd__tapvpwrvgnd_1
XFILLER_26_669 VPWR VGND VPWR VGND sky130_ef_sc_hd__decap_12
XFILLER_80_274 VGND VGND VPWR VPWR sky130_fd_sc_hd__decap_4
X_5937_ _1774_ _1777_ _1778_ VGND VGND VPWR VPWR _1780_ sky130_fd_sc_hd__nand3_1
XFILLER_13_319 VPWR VGND VPWR VGND sky130_ef_sc_hd__decap_12
XTAP_TAPCELL_ROW_36_686 VGND VPWR sky130_fd_sc_hd__tapvpwrvgnd_1
XFILLER_41_617 VPWR VGND VPWR VGND sky130_ef_sc_hd__decap_12
X_5868_ _1656_ _1657_ _1701_ _1702_ VGND VGND VPWR VPWR _1705_ sky130_fd_sc_hd__o22a_1
X_4819_ _0479_ _0486_ _0485_ VGND VGND VPWR VPWR _0579_ sky130_fd_sc_hd__a21o_1
XTAP_TAPCELL_ROW_97_1419 VGND VPWR sky130_fd_sc_hd__tapvpwrvgnd_1
X_5799_ _1619_ _1628_ VGND VGND VPWR VPWR _1629_ sky130_fd_sc_hd__xor2_1
XFILLER_5_529 VPWR VGND VPWR VGND sky130_ef_sc_hd__decap_12
XFILLER_31_57 VPWR VGND VPWR VGND sky130_ef_sc_hd__decap_12
XTAP_TAPCELL_ROW_8_345 VGND VPWR sky130_fd_sc_hd__tapvpwrvgnd_1
Xoutput79 net79 VGND VGND VPWR VPWR return_port[11] sky130_fd_sc_hd__clkbuf_4
XFILLER_103_641 VPWR VGND VPWR VGND sky130_ef_sc_hd__decap_12
XFILLER_0_223 VGND VGND VPWR VPWR sky130_fd_sc_hd__fill_1
XFILLER_103_685 VGND VGND VPWR VPWR sky130_fd_sc_hd__decap_6
XFILLER_102_184 VPWR VGND VPWR VGND sky130_ef_sc_hd__decap_12
XFILLER_76_569 VGND VGND VPWR VPWR sky130_fd_sc_hd__decap_4
XTAP_TAPCELL_ROW_106_1526 VGND VPWR sky130_fd_sc_hd__tapvpwrvgnd_1
XFILLER_17_614 VGND VGND VPWR VPWR sky130_fd_sc_hd__fill_2
XPHY_EDGE_ROW_19_Right_19 VGND VGND VPWR VPWR sky130_fd_sc_hd__decap_3
XFILLER_44_433 VPWR VGND VPWR VGND sky130_ef_sc_hd__decap_12
XFILLER_31_105 VGND VGND VPWR VPWR sky130_fd_sc_hd__decap_6
XFILLER_44_477 VGND VGND VPWR VPWR sky130_fd_sc_hd__decap_8
XFILLER_25_691 VGND VGND VPWR VPWR sky130_fd_sc_hd__fill_1
XFILLER_31_149 VGND VGND VPWR VPWR sky130_fd_sc_hd__decap_4
XFILLER_99_617 VPWR VGND VPWR VGND sky130_ef_sc_hd__decap_12
XPHY_EDGE_ROW_28_Right_28 VGND VGND VPWR VPWR sky130_fd_sc_hd__decap_3
XFILLER_113_416 VPWR VGND VPWR VGND sky130_ef_sc_hd__decap_12
XFILLER_98_116 VGND VGND VPWR VPWR sky130_fd_sc_hd__fill_2
XFILLER_113_449 VPWR VGND VPWR VGND sky130_ef_sc_hd__decap_12
XFILLER_94_300 VGND VGND VPWR VPWR sky130_fd_sc_hd__fill_1
XFILLER_39_216 VGND VGND VPWR VPWR sky130_fd_sc_hd__decap_8
XFILLER_35_400 VPWR VGND VPWR VGND sky130_ef_sc_hd__decap_12
XPHY_EDGE_ROW_37_Right_37 VGND VGND VPWR VPWR sky130_fd_sc_hd__decap_3
XFILLER_47_260 VGND VGND VPWR VPWR sky130_fd_sc_hd__fill_1
X_6840_ _2763_ _2764_ VGND VGND VPWR VPWR _2765_ sky130_fd_sc_hd__xnor2_1
XFILLER_23_617 VPWR VGND VPWR VGND sky130_ef_sc_hd__decap_12
X_6771_ net437 net205 VGND VGND VPWR VPWR _2689_ sky130_fd_sc_hd__nand2_1
XFILLER_50_414 VGND VGND VPWR VPWR sky130_fd_sc_hd__decap_6
XFILLER_62_296 VPWR VGND VPWR VGND sky130_ef_sc_hd__decap_12
X_5722_ _1398_ _1401_ _1399_ VGND VGND VPWR VPWR _1545_ sky130_fd_sc_hd__o21bai_1
XTAP_TAPCELL_ROW_33_645 VGND VPWR sky130_fd_sc_hd__tapvpwrvgnd_1
X_3983_ net123 _3170_ _3171_ _3167_ VGND VGND VPWR VPWR _3172_ sky130_fd_sc_hd__a31o_1
XTAP_TAPCELL_ROW_61_987 VGND VPWR sky130_fd_sc_hd__tapvpwrvgnd_1
X_5653_ _1467_ _1468_ VGND VGND VPWR VPWR _1469_ sky130_fd_sc_hd__and2_1
X_4604_ _0364_ _0365_ _0354_ VGND VGND VPWR VPWR _0367_ sky130_fd_sc_hd__a21o_1
X_5584_ _1269_ _1393_ VGND VGND VPWR VPWR _1394_ sky130_fd_sc_hd__and2_1
XFILLER_30_193 VGND VGND VPWR VPWR sky130_fd_sc_hd__decap_3
XPHY_EDGE_ROW_46_Right_46 VGND VGND VPWR VPWR sky130_fd_sc_hd__decap_3
XFILLER_116_221 VGND VGND VPWR VPWR sky130_fd_sc_hd__decap_3
X_4535_ net229 net392 net381 net242 VGND VGND VPWR VPWR _0299_ sky130_fd_sc_hd__a22o_1
XFILLER_116_298 VGND VGND VPWR VPWR sky130_fd_sc_hd__fill_1
X_4466_ _0183_ _0185_ _0182_ VGND VGND VPWR VPWR _0232_ sky130_fd_sc_hd__a21bo_1
X_4397_ net249 net399 _0162_ _0163_ VGND VGND VPWR VPWR _0164_ sky130_fd_sc_hd__a22o_1
XFILLER_89_138 VPWR VGND VPWR VGND sky130_ef_sc_hd__decap_12
X_6205_ _0841_ _0928_ _2068_ _2069_ VGND VGND VPWR VPWR _2071_ sky130_fd_sc_hd__o22a_1
X_3417_ net428 VGND VGND VPWR VPWR _0895_ sky130_fd_sc_hd__inv_2
XTAP_TAPCELL_ROW_5_315 VGND VPWR sky130_fd_sc_hd__tapvpwrvgnd_1
X_6136_ _1835_ _1839_ _1992_ _1994_ VGND VGND VPWR VPWR _1996_ sky130_fd_sc_hd__a211o_1
XFILLER_73_517 VGND VGND VPWR VPWR sky130_fd_sc_hd__fill_1
XPHY_EDGE_ROW_55_Right_55 VGND VGND VPWR VPWR sky130_fd_sc_hd__decap_3
X_6067_ net368 net302 _1747_ _1745_ VGND VGND VPWR VPWR _1921_ sky130_fd_sc_hd__a31o_1
X_5018_ _0774_ _0775_ _0684_ VGND VGND VPWR VPWR _0778_ sky130_fd_sc_hd__a21oi_1
XFILLER_85_388 VGND VGND VPWR VPWR sky130_fd_sc_hd__decap_4
XFILLER_38_282 VPWR VGND VPWR VGND sky130_ef_sc_hd__decap_12
XFILLER_26_477 VPWR VGND VPWR VGND sky130_ef_sc_hd__decap_12
XFILLER_53_296 VGND VGND VPWR VPWR sky130_fd_sc_hd__decap_8
XTAP_TAPCELL_ROW_101_1467 VGND VPWR sky130_fd_sc_hd__tapvpwrvgnd_1
XPHY_EDGE_ROW_64_Right_64 VGND VGND VPWR VPWR sky130_fd_sc_hd__decap_3
XFILLER_21_193 VGND VGND VPWR VPWR sky130_fd_sc_hd__decap_8
XFILLER_5_348 VGND VGND VPWR VPWR sky130_fd_sc_hd__fill_2
XFILLER_107_276 VGND VGND VPWR VPWR sky130_fd_sc_hd__decap_4
XFILLER_110_419 VGND VGND VPWR VPWR sky130_fd_sc_hd__fill_1
XFILLER_3_39 VPWR VGND VPWR VGND sky130_ef_sc_hd__decap_12
XTAP_TAPCELL_ROW_112_1596 VGND VPWR sky130_fd_sc_hd__tapvpwrvgnd_1
XFILLER_76_333 VPWR VGND VPWR VGND sky130_ef_sc_hd__decap_12
XPHY_EDGE_ROW_73_Right_73 VGND VGND VPWR VPWR sky130_fd_sc_hd__decap_3
XFILLER_67_64 VGND VGND VPWR VPWR sky130_fd_sc_hd__fill_1
XFILLER_49_536 VGND VGND VPWR VPWR sky130_fd_sc_hd__fill_2
XFILLER_76_377 VGND VGND VPWR VPWR sky130_fd_sc_hd__decap_4
XFILLER_29_271 VGND VGND VPWR VPWR sky130_fd_sc_hd__decap_8
XFILLER_17_433 VGND VGND VPWR VPWR sky130_fd_sc_hd__fill_2
XTAP_TAPCELL_ROW_67_1053 VGND VPWR sky130_fd_sc_hd__tapvpwrvgnd_1
XFILLER_17_488 VPWR VGND VPWR VGND sky130_ef_sc_hd__decap_12
XPHY_EDGE_ROW_17_Left_134 VGND VGND VPWR VPWR sky130_fd_sc_hd__decap_3
XFILLER_32_436 VGND VGND VPWR VPWR sky130_fd_sc_hd__decap_6
XFILLER_44_296 VPWR VGND VPWR VGND sky130_ef_sc_hd__decap_12
XPHY_EDGE_ROW_82_Right_82 VGND VGND VPWR VPWR sky130_fd_sc_hd__decap_3
XTAP_TAPCELL_ROW_30_615 VGND VPWR sky130_fd_sc_hd__tapvpwrvgnd_1
XFILLER_9_665 VGND VGND VPWR VPWR sky130_fd_sc_hd__decap_6
XTAP_TAPCELL_ROW_10_372 VGND VPWR sky130_fd_sc_hd__tapvpwrvgnd_1
X_4320_ _0088_ _0089_ _0069_ VGND VGND VPWR VPWR _0090_ sky130_fd_sc_hd__a21o_1
XTAP_TAPCELL_ROW_78_1193 VGND VPWR sky130_fd_sc_hd__tapvpwrvgnd_1
XTAP_TAPCELL_ROW_78_1182 VGND VPWR sky130_fd_sc_hd__tapvpwrvgnd_1
X_4251_ _3089_ _3134_ _3307_ _2910_ _0026_ VGND VGND VPWR VPWR _0027_ sky130_fd_sc_hd__a221o_1
XFILLER_4_381 VPWR VGND VPWR VGND sky130_ef_sc_hd__decap_12
XPHY_EDGE_ROW_26_Left_143 VGND VGND VPWR VPWR sky130_fd_sc_hd__decap_3
XFILLER_113_279 VGND VGND VPWR VPWR sky130_fd_sc_hd__fill_1
XPHY_EDGE_ROW_91_Right_91 VGND VGND VPWR VPWR sky130_fd_sc_hd__decap_3
XFILLER_86_108 VGND VGND VPWR VPWR sky130_fd_sc_hd__fill_1
XFILLER_67_300 VGND VGND VPWR VPWR sky130_fd_sc_hd__fill_1
X_4182_ net346 _0895_ _2150_ VGND VGND VPWR VPWR _3362_ sky130_fd_sc_hd__o21ai_1
XFILLER_95_653 VPWR VGND VPWR VGND sky130_ef_sc_hd__decap_12
XFILLER_94_152 VGND VGND VPWR VPWR sky130_fd_sc_hd__decap_4
XFILLER_94_141 VGND VGND VPWR VPWR sky130_fd_sc_hd__decap_4
XFILLER_67_355 VGND VGND VPWR VPWR sky130_fd_sc_hd__fill_1
XFILLER_55_517 VPWR VGND VPWR VGND sky130_ef_sc_hd__decap_12
XFILLER_27_208 VGND VGND VPWR VPWR sky130_fd_sc_hd__fill_1
XTAP_TAPCELL_ROW_38_704 VGND VPWR sky130_fd_sc_hd__tapvpwrvgnd_1
XFILLER_82_336 VGND VGND VPWR VPWR sky130_fd_sc_hd__decap_3
XFILLER_63_583 VGND VGND VPWR VPWR sky130_fd_sc_hd__decap_3
XPHY_EDGE_ROW_35_Left_152 VGND VGND VPWR VPWR sky130_fd_sc_hd__decap_3
XFILLER_35_241 VPWR VGND VPWR VGND sky130_ef_sc_hd__decap_12
XTAP_TAPCELL_ROW_18_472 VGND VPWR sky130_fd_sc_hd__tapvpwrvgnd_1
X_6823_ _2730_ _2745_ VGND VGND VPWR VPWR _2746_ sky130_fd_sc_hd__xnor2_1
XFILLER_23_436 VGND VGND VPWR VPWR sky130_fd_sc_hd__decap_6
XFILLER_50_222 VGND VGND VPWR VPWR sky130_fd_sc_hd__fill_1
X_3966_ net232 _3155_ VGND VGND VPWR VPWR _3156_ sky130_fd_sc_hd__or2_1
XFILLER_11_609 VGND VGND VPWR VPWR sky130_fd_sc_hd__decap_6
X_6754_ _2600_ _2642_ _2640_ VGND VGND VPWR VPWR _2670_ sky130_fd_sc_hd__o21a_1
X_6685_ _2555_ _2594_ VGND VGND VPWR VPWR _2595_ sky130_fd_sc_hd__xor2_1
X_5705_ _1523_ _1524_ _1434_ VGND VGND VPWR VPWR _1526_ sky130_fd_sc_hd__o21ai_1
X_3897_ _2498_ _2531_ _2586_ _2509_ net236 net162 VGND VGND VPWR VPWR _3090_ sky130_fd_sc_hd__mux4_1
X_5636_ _1446_ _1448_ _1227_ _1229_ VGND VGND VPWR VPWR _1451_ sky130_fd_sc_hd__o211a_1
XFILLER_12_15 VPWR VGND VPWR VGND sky130_ef_sc_hd__decap_12
XFILLER_31_491 VPWR VGND VPWR VGND sky130_ef_sc_hd__decap_12
X_5567_ _1309_ _1373_ _1374_ VGND VGND VPWR VPWR _1376_ sky130_fd_sc_hd__nand3_2
X_4518_ _0280_ _0281_ _0224_ _0226_ VGND VGND VPWR VPWR _0283_ sky130_fd_sc_hd__a211o_1
X_5498_ _1297_ _1298_ _1294_ VGND VGND VPWR VPWR _1301_ sky130_fd_sc_hd__a21o_1
XPHY_EDGE_ROW_44_Left_161 VGND VGND VPWR VPWR sky130_fd_sc_hd__decap_3
X_4449_ _0198_ _0213_ _0214_ VGND VGND VPWR VPWR _0215_ sky130_fd_sc_hd__and3_1
XFILLER_104_246 VGND VGND VPWR VPWR sky130_fd_sc_hd__decap_6
XFILLER_58_333 VGND VGND VPWR VPWR sky130_fd_sc_hd__decap_3
X_6119_ _1974_ _1976_ _1970_ VGND VGND VPWR VPWR _1978_ sky130_fd_sc_hd__a21o_1
XFILLER_85_163 VGND VGND VPWR VPWR sky130_fd_sc_hd__fill_1
XFILLER_73_303 VGND VGND VPWR VPWR sky130_fd_sc_hd__decap_8
XFILLER_58_377 VPWR VGND VPWR VGND sky130_ef_sc_hd__decap_12
XFILLER_73_358 VPWR VGND VPWR VGND sky130_ef_sc_hd__decap_12
XPHY_EDGE_ROW_53_Left_170 VGND VGND VPWR VPWR sky130_fd_sc_hd__decap_3
XFILLER_6_613 VPWR VGND VPWR VGND sky130_ef_sc_hd__decap_12
XFILLER_108_530 VGND VGND VPWR VPWR sky130_fd_sc_hd__fill_2
XFILLER_6_657 VPWR VGND VPWR VGND sky130_ef_sc_hd__decap_12
XTAP_TAPCELL_ROW_114_1625 VGND VPWR sky130_fd_sc_hd__tapvpwrvgnd_1
XTAP_TAPCELL_ROW_114_1614 VGND VPWR sky130_fd_sc_hd__tapvpwrvgnd_1
XFILLER_78_74 VGND VGND VPWR VPWR sky130_fd_sc_hd__decap_4
XFILLER_110_238 VPWR VGND VPWR VGND sky130_ef_sc_hd__decap_12
XFILLER_96_439 VPWR VGND VPWR VGND sky130_ef_sc_hd__decap_12
XFILLER_89_491 VPWR VGND VPWR VGND sky130_ef_sc_hd__decap_12
XFILLER_49_322 VPWR VGND VPWR VGND sky130_ef_sc_hd__decap_12
XFILLER_92_601 VPWR VGND VPWR VGND sky130_ef_sc_hd__decap_12
XFILLER_77_653 VPWR VGND VPWR VGND sky130_ef_sc_hd__decap_12
XFILLER_76_141 VPWR VGND VPWR VGND sky130_ef_sc_hd__decap_12
XFILLER_91_111 VGND VGND VPWR VPWR sky130_fd_sc_hd__fill_1
XFILLER_76_174 VPWR VGND VPWR VGND sky130_ef_sc_hd__decap_12
XFILLER_94_95 VPWR VGND VPWR VGND sky130_ef_sc_hd__decap_12
XFILLER_92_645 VPWR VGND VPWR VGND sky130_ef_sc_hd__decap_12
XFILLER_92_689 VGND VGND VPWR VPWR sky130_fd_sc_hd__decap_3
XFILLER_91_155 VPWR VGND VPWR VGND sky130_ef_sc_hd__decap_12
X_3820_ net130 _3005_ _3015_ _3002_ _1550_ VGND VGND VPWR VPWR _3016_ sky130_fd_sc_hd__o221a_1
XTAP_TAPCELL_ROW_15_431 VGND VPWR sky130_fd_sc_hd__tapvpwrvgnd_1
XTAP_TAPCELL_ROW_43_762 VGND VPWR sky130_fd_sc_hd__tapvpwrvgnd_1
X_3751_ _2921_ _2923_ _2949_ VGND VGND VPWR VPWR _2950_ sky130_fd_sc_hd__a21oi_2
XTAP_TAPCELL_ROW_43_773 VGND VPWR sky130_fd_sc_hd__tapvpwrvgnd_1
XFILLER_71_3 VPWR VGND VPWR VGND sky130_ef_sc_hd__decap_12
X_3682_ _2883_ VGND VGND VPWR VPWR _2884_ sky130_fd_sc_hd__inv_2
X_6470_ _2359_ _2360_ VGND VGND VPWR VPWR _2361_ sky130_fd_sc_hd__nor2_1
X_5421_ net235 net230 net169 VGND VGND VPWR VPWR _1216_ sky130_fd_sc_hd__and3_1
X_5352_ _1138_ _1139_ _1075_ VGND VGND VPWR VPWR _1141_ sky130_fd_sc_hd__a21oi_1
XFILLER_114_533 VPWR VGND VPWR VGND sky130_ef_sc_hd__decap_12
X_4303_ _0072_ VGND VGND VPWR VPWR _0073_ sky130_fd_sc_hd__inv_2
X_5283_ _1064_ _1065_ VGND VGND VPWR VPWR _1066_ sky130_fd_sc_hd__xor2_1
X_4234_ _0009_ VGND VGND VPWR VPWR _0010_ sky130_fd_sc_hd__inv_2
X_4165_ net244 _3260_ _3345_ VGND VGND VPWR VPWR _3346_ sky130_fd_sc_hd__a21o_1
XFILLER_95_494 VGND VGND VPWR VPWR sky130_fd_sc_hd__decap_3
XFILLER_67_185 VGND VGND VPWR VPWR sky130_fd_sc_hd__fill_2
XFILLER_55_314 VPWR VGND VPWR VGND sky130_ef_sc_hd__decap_12
X_4096_ _3106_ _3279_ net152 VGND VGND VPWR VPWR _3280_ sky130_fd_sc_hd__mux2_1
XFILLER_55_358 VPWR VGND VPWR VGND sky130_ef_sc_hd__decap_12
XFILLER_82_188 VGND VGND VPWR VPWR sky130_fd_sc_hd__decap_8
XFILLER_63_391 VGND VGND VPWR VPWR sky130_fd_sc_hd__fill_1
X_6806_ _2716_ _2723_ VGND VGND VPWR VPWR _2727_ sky130_fd_sc_hd__xnor2_1
X_4998_ _0753_ _0754_ _0750_ VGND VGND VPWR VPWR _0756_ sky130_fd_sc_hd__a21o_1
XFILLER_109_305 VPWR VGND VPWR VGND sky130_ef_sc_hd__decap_12
X_3949_ _1561_ _3138_ _3139_ _1615_ _3134_ VGND VGND VPWR VPWR _3140_ sky130_fd_sc_hd__a32o_1
X_6737_ _2651_ VGND VGND VPWR VPWR _2653_ sky130_fd_sc_hd__inv_2
X_6668_ net175 net306 VGND VGND VPWR VPWR _2577_ sky130_fd_sc_hd__nand2_1
XFILLER_109_349 VPWR VGND VPWR VGND sky130_ef_sc_hd__decap_12
X_6599_ net451 net56 VGND VGND VPWR VPWR _2501_ sky130_fd_sc_hd__nand2_1
X_5619_ _1429_ _1431_ _1305_ _1307_ VGND VGND VPWR VPWR _1433_ sky130_fd_sc_hd__o211a_1
XFILLER_2_126 VGND VGND VPWR VPWR sky130_fd_sc_hd__decap_4
Xfanout441 net16 VGND VGND VPWR VPWR net441 sky130_fd_sc_hd__clkbuf_4
Xfanout430 net2 VGND VGND VPWR VPWR net430 sky130_fd_sc_hd__clkbuf_4
Xfanout474 net475 VGND VGND VPWR VPWR net474 sky130_fd_sc_hd__clkbuf_4
XFILLER_59_653 VPWR VGND VPWR VGND sky130_ef_sc_hd__decap_12
XFILLER_58_141 VPWR VGND VPWR VGND sky130_ef_sc_hd__decap_12
Xfanout452 net459 VGND VGND VPWR VPWR net452 sky130_fd_sc_hd__clkbuf_2
Xfanout463 net11 VGND VGND VPWR VPWR net463 sky130_fd_sc_hd__buf_1
XFILLER_74_634 VGND VGND VPWR VPWR sky130_fd_sc_hd__decap_8
XFILLER_74_601 VGND VGND VPWR VPWR sky130_fd_sc_hd__decap_3
XFILLER_58_174 VPWR VGND VPWR VGND sky130_ef_sc_hd__decap_12
XFILLER_19_517 VPWR VGND VPWR VGND sky130_ef_sc_hd__decap_12
XFILLER_19_539 VPWR VGND VPWR VGND sky130_ef_sc_hd__decap_12
XFILLER_46_303 VGND VGND VPWR VPWR sky130_fd_sc_hd__decap_4
XFILLER_74_645 VPWR VGND VPWR VGND sky130_ef_sc_hd__decap_12
XFILLER_73_111 VGND VGND VPWR VPWR sky130_fd_sc_hd__fill_1
XFILLER_0_29 VPWR VGND VPWR VGND sky130_ef_sc_hd__decap_12
XFILLER_104_83 VGND VGND VPWR VPWR sky130_fd_sc_hd__fill_1
XFILLER_74_689 VGND VGND VPWR VPWR sky130_fd_sc_hd__decap_3
XFILLER_27_561 VGND VGND VPWR VPWR sky130_fd_sc_hd__decap_3
XTAP_TAPCELL_ROW_64_1023 VGND VPWR sky130_fd_sc_hd__tapvpwrvgnd_1
XFILLER_14_222 VGND VGND VPWR VPWR sky130_fd_sc_hd__fill_1
XFILLER_42_520 VGND VGND VPWR VPWR sky130_fd_sc_hd__decap_4
XFILLER_42_531 VGND VGND VPWR VPWR sky130_fd_sc_hd__fill_1
XFILLER_9_27 VPWR VGND VPWR VGND sky130_ef_sc_hd__decap_12
XFILLER_42_564 VGND VGND VPWR VPWR sky130_fd_sc_hd__fill_1
XTAP_TAPCELL_ROW_12_401 VGND VPWR sky130_fd_sc_hd__tapvpwrvgnd_1
XFILLER_42_586 VGND VGND VPWR VPWR sky130_fd_sc_hd__fill_2
XTAP_TAPCELL_ROW_40_732 VGND VPWR sky130_fd_sc_hd__tapvpwrvgnd_1
XFILLER_6_421 VPWR VGND VPWR VGND sky130_ef_sc_hd__decap_12
XFILLER_115_319 VGND VGND VPWR VPWR sky130_fd_sc_hd__fill_2
XPHY_EDGE_ROW_108_Right_108 VGND VGND VPWR VPWR sky130_fd_sc_hd__decap_3
XFILLER_108_382 VPWR VGND VPWR VGND sky130_ef_sc_hd__decap_12
XTAP_TAPCELL_ROW_75_1152 VGND VPWR sky130_fd_sc_hd__tapvpwrvgnd_1
XFILLER_43_7 VPWR VGND VPWR VGND sky130_ef_sc_hd__decap_12
XFILLER_49_141 VPWR VGND VPWR VGND sky130_ef_sc_hd__decap_12
XFILLER_77_461 VGND VGND VPWR VPWR sky130_fd_sc_hd__fill_2
XFILLER_77_494 VGND VGND VPWR VPWR sky130_fd_sc_hd__decap_6
XTAP_TAPCELL_ROW_48_832 VGND VPWR sky130_fd_sc_hd__tapvpwrvgnd_1
X_5970_ _1408_ _1815_ VGND VGND VPWR VPWR _1816_ sky130_fd_sc_hd__and2_1
XFILLER_52_317 VPWR VGND VPWR VGND sky130_ef_sc_hd__decap_12
X_4921_ _0676_ _0677_ _0660_ VGND VGND VPWR VPWR _0680_ sky130_fd_sc_hd__a21oi_1
XTAP_TAPCELL_ROW_86_1281 VGND VPWR sky130_fd_sc_hd__tapvpwrvgnd_1
XFILLER_45_380 VGND VGND VPWR VPWR sky130_fd_sc_hd__fill_1
X_4852_ _0609_ _0610_ _0501_ _0503_ VGND VGND VPWR VPWR _0612_ sky130_fd_sc_hd__a211o_1
XFILLER_33_542 VGND VGND VPWR VPWR sky130_fd_sc_hd__decap_3
X_3803_ _1561_ _2998_ _2999_ net118 VGND VGND VPWR VPWR _3000_ sky130_fd_sc_hd__a22o_1
X_4783_ net475 net321 VGND VGND VPWR VPWR _0543_ sky130_fd_sc_hd__nand2_1
X_3734_ _2932_ _2933_ net232 VGND VGND VPWR VPWR _2934_ sky130_fd_sc_hd__mux2_1
X_6522_ _2402_ _2417_ VGND VGND VPWR VPWR _2418_ sky130_fd_sc_hd__or2_1
X_3665_ _1266_ _2860_ _2863_ net122 _2867_ VGND VGND VPWR VPWR _2868_ sky130_fd_sc_hd__a221o_1
XFILLER_9_281 VGND VGND VPWR VPWR sky130_fd_sc_hd__decap_8
X_6453_ _2334_ _2340_ VGND VGND VPWR VPWR _2342_ sky130_fd_sc_hd__xnor2_1
XFILLER_109_39 VPWR VGND VPWR VGND sky130_ef_sc_hd__decap_12
X_5404_ _1195_ _1196_ _1079_ _1083_ VGND VGND VPWR VPWR _1198_ sky130_fd_sc_hd__o211ai_2
X_3596_ _2739_ _2799_ VGND VGND VPWR VPWR _2801_ sky130_fd_sc_hd__and2_1
X_6384_ _2265_ _2266_ VGND VGND VPWR VPWR _2267_ sky130_fd_sc_hd__nor2_1
X_5335_ net221 net207 net200 net262 VGND VGND VPWR VPWR _1122_ sky130_fd_sc_hd__a22o_1
X_5266_ _1044_ _1046_ VGND VGND VPWR VPWR _1047_ sky130_fd_sc_hd__xor2_1
X_4217_ _3393_ _3394_ VGND VGND VPWR VPWR _3395_ sky130_fd_sc_hd__xnor2_1
X_5197_ _0938_ _0971_ VGND VGND VPWR VPWR _0973_ sky130_fd_sc_hd__nand2_1
XFILLER_68_472 VGND VGND VPWR VPWR sky130_fd_sc_hd__decap_4
XFILLER_55_100 VPWR VGND VPWR VGND sky130_ef_sc_hd__decap_12
X_4148_ _2977_ _3134_ _3307_ _2259_ _3329_ VGND VGND VPWR VPWR _3330_ sky130_fd_sc_hd__a221o_1
XFILLER_56_645 VPWR VGND VPWR VGND sky130_ef_sc_hd__decap_12
XFILLER_71_615 VGND VGND VPWR VPWR sky130_fd_sc_hd__fill_1
X_4079_ net231 _3087_ _3262_ _1572_ VGND VGND VPWR VPWR _3264_ sky130_fd_sc_hd__a211o_1
XFILLER_56_689 VGND VGND VPWR VPWR sky130_fd_sc_hd__decap_3
XFILLER_70_103 VPWR VGND VPWR VGND sky130_ef_sc_hd__decap_12
XFILLER_70_158 VGND VGND VPWR VPWR sky130_fd_sc_hd__fill_2
XTAP_TAPCELL_ROW_26_559 VGND VPWR sky130_fd_sc_hd__tapvpwrvgnd_1
XFILLER_11_214 VGND VGND VPWR VPWR sky130_fd_sc_hd__decap_8
XFILLER_109_113 VGND VGND VPWR VPWR sky130_fd_sc_hd__fill_2
XFILLER_109_146 VPWR VGND VPWR VGND sky130_ef_sc_hd__decap_12
XFILLER_50_78 VGND VGND VPWR VPWR sky130_fd_sc_hd__decap_6
XFILLER_1_3 VPWR VGND VPWR VGND sky130_ef_sc_hd__decap_12
XFILLER_59_54 VGND VGND VPWR VPWR sky130_fd_sc_hd__fill_2
Xfanout260 net261 VGND VGND VPWR VPWR net260 sky130_fd_sc_hd__buf_2
Xfanout282 net283 VGND VGND VPWR VPWR net282 sky130_fd_sc_hd__clkbuf_4
XFILLER_59_461 VGND VGND VPWR VPWR sky130_fd_sc_hd__decap_8
Xfanout271 net273 VGND VGND VPWR VPWR net271 sky130_fd_sc_hd__clkbuf_4
XFILLER_115_93 VPWR VGND VPWR VGND sky130_ef_sc_hd__decap_12
XFILLER_93_239 VGND VGND VPWR VPWR sky130_fd_sc_hd__decap_3
XTAP_TAPCELL_ROW_70_1093 VGND VPWR sky130_fd_sc_hd__tapvpwrvgnd_1
Xfanout293 net295 VGND VGND VPWR VPWR net293 sky130_fd_sc_hd__buf_2
XTAP_TAPCELL_ROW_109_1557 VGND VPWR sky130_fd_sc_hd__tapvpwrvgnd_1
XFILLER_46_166 VGND VGND VPWR VPWR sky130_fd_sc_hd__decap_8
XFILLER_61_103 VGND VGND VPWR VPWR sky130_fd_sc_hd__decap_8
XFILLER_34_328 VPWR VGND VPWR VGND sky130_ef_sc_hd__decap_12
XFILLER_61_169 VGND VGND VPWR VPWR sky130_fd_sc_hd__decap_8
XFILLER_61_147 VPWR VGND VPWR VGND sky130_ef_sc_hd__decap_12
XFILLER_70_681 VGND VGND VPWR VPWR sky130_fd_sc_hd__decap_8
XFILLER_15_597 VPWR VGND VPWR VGND sky130_ef_sc_hd__decap_12
XFILLER_42_372 VGND VGND VPWR VPWR sky130_fd_sc_hd__decap_4
XTAP_TAPCELL_ROW_53_890 VGND VPWR sky130_fd_sc_hd__tapvpwrvgnd_1
XFILLER_30_523 VGND VGND VPWR VPWR sky130_fd_sc_hd__fill_2
XFILLER_115_105 VGND VGND VPWR VPWR sky130_fd_sc_hd__decap_6
XFILLER_6_251 VGND VGND VPWR VPWR sky130_fd_sc_hd__fill_1
XFILLER_115_149 VGND VGND VPWR VPWR sky130_fd_sc_hd__fill_1
XFILLER_109_691 VGND VGND VPWR VPWR sky130_fd_sc_hd__fill_1
X_3450_ _1048_ _1124_ VGND VGND VPWR VPWR _1255_ sky130_fd_sc_hd__or2_1
XFILLER_108_190 VGND VGND VPWR VPWR sky130_fd_sc_hd__decap_6
X_5120_ _0887_ _0888_ VGND VGND VPWR VPWR _0889_ sky130_fd_sc_hd__xnor2_1
XFILLER_69_225 VPWR VGND VPWR VGND sky130_ef_sc_hd__decap_12
XFILLER_34_3 VPWR VGND VPWR VGND sky130_ef_sc_hd__decap_12
X_5051_ _0811_ _0812_ VGND VGND VPWR VPWR _0813_ sky130_fd_sc_hd__nor2_1
XFILLER_111_377 VPWR VGND VPWR VGND sky130_ef_sc_hd__decap_12
X_4002_ net138 _3183_ _3184_ net145 net132 VGND VGND VPWR VPWR _3190_ sky130_fd_sc_hd__a221o_1
XTAP_TAPCELL_ROW_88_1310 VGND VPWR sky130_fd_sc_hd__tapvpwrvgnd_1
XFILLER_77_291 VGND VGND VPWR VPWR sky130_fd_sc_hd__decap_3
XFILLER_38_645 VPWR VGND VPWR VGND sky130_ef_sc_hd__decap_12
XFILLER_37_166 VGND VGND VPWR VPWR sky130_fd_sc_hd__fill_2
XFILLER_38_689 VGND VGND VPWR VPWR sky130_fd_sc_hd__decap_3
XFILLER_92_272 VPWR VGND VPWR VGND sky130_ef_sc_hd__decap_12
XFILLER_65_497 VGND VGND VPWR VPWR sky130_fd_sc_hd__fill_1
XPHY_EDGE_ROW_9_Left_126 VGND VGND VPWR VPWR sky130_fd_sc_hd__decap_3
X_5953_ _1756_ _1758_ _1794_ _1796_ VGND VGND VPWR VPWR _1797_ sky130_fd_sc_hd__o22a_1
XFILLER_18_391 VPWR VGND VPWR VGND sky130_ef_sc_hd__decap_12
X_4904_ net393 net195 _0546_ _0545_ VGND VGND VPWR VPWR _0663_ sky130_fd_sc_hd__a31o_1
X_5884_ _1580_ _1720_ _1458_ VGND VGND VPWR VPWR _1722_ sky130_fd_sc_hd__o21a_1
XTAP_TAPCELL_ROW_23_529 VGND VPWR sky130_fd_sc_hd__tapvpwrvgnd_1
XFILLER_40_309 VGND VGND VPWR VPWR sky130_fd_sc_hd__decap_4
X_4835_ _0516_ _0518_ _0592_ _0594_ VGND VGND VPWR VPWR _0595_ sky130_fd_sc_hd__a211o_1
X_4766_ _0488_ _0525_ _0526_ VGND VGND VPWR VPWR _0527_ sky130_fd_sc_hd__nor3_1
XFILLER_21_589 VPWR VGND VPWR VGND sky130_ef_sc_hd__decap_12
X_3717_ _2906_ _2907_ _2917_ VGND VGND VPWR VPWR _alu_i0.Datapath_i.fu_alu_33673_33851.out1\[6\]
+ sky130_fd_sc_hd__a21o_1
X_6505_ _2389_ _2398_ VGND VGND VPWR VPWR _2399_ sky130_fd_sc_hd__and2_1
XFILLER_107_617 VPWR VGND VPWR VGND sky130_ef_sc_hd__decap_12
X_4697_ _0390_ _0457_ _0458_ VGND VGND VPWR VPWR _0459_ sky130_fd_sc_hd__and3_1
XFILLER_20_15 VPWR VGND VPWR VGND sky130_ef_sc_hd__decap_12
X_3648_ _2844_ _2850_ VGND VGND VPWR VPWR _2851_ sky130_fd_sc_hd__and2_1
X_6436_ _2164_ _2166_ VGND VGND VPWR VPWR _2324_ sky130_fd_sc_hd__nor2_1
XFILLER_88_501 VPWR VGND VPWR VGND sky130_ef_sc_hd__decap_12
X_3579_ net473 net280 VGND VGND VPWR VPWR _2663_ sky130_fd_sc_hd__nand2_1
X_6367_ _2038_ _2043_ _2246_ VGND VGND VPWR VPWR _2249_ sky130_fd_sc_hd__nor3_1
XFILLER_114_160 VGND VGND VPWR VPWR sky130_fd_sc_hd__decap_8
X_5318_ net224 net173 net169 net236 VGND VGND VPWR VPWR _1104_ sky130_fd_sc_hd__a22o_1
XFILLER_102_322 VPWR VGND VPWR VGND sky130_ef_sc_hd__decap_12
XFILLER_88_567 VGND VGND VPWR VPWR sky130_fd_sc_hd__fill_1
X_6298_ net147 _2173_ _2017_ VGND VGND VPWR VPWR net96 sky130_fd_sc_hd__a21oi_2
XFILLER_0_449 VPWR VGND VPWR VGND sky130_ef_sc_hd__decap_12
XFILLER_102_377 VGND VGND VPWR VPWR sky130_fd_sc_hd__decap_3
XFILLER_88_589 VPWR VGND VPWR VGND sky130_ef_sc_hd__decap_12
X_5249_ _1025_ _1027_ _0915_ _0919_ VGND VGND VPWR VPWR _1029_ sky130_fd_sc_hd__o211a_1
XFILLER_29_57 VPWR VGND VPWR VGND sky130_ef_sc_hd__decap_12
XFILLER_90_209 VGND VGND VPWR VPWR sky130_fd_sc_hd__fill_2
XFILLER_56_475 VGND VGND VPWR VPWR sky130_fd_sc_hd__fill_1
XTAP_TAPCELL_ROW_3_287 VGND VPWR sky130_fd_sc_hd__tapvpwrvgnd_1
XFILLER_28_133 VGND VGND VPWR VPWR sky130_fd_sc_hd__decap_6
XFILLER_28_177 VPWR VGND VPWR VGND sky130_ef_sc_hd__decap_12
XFILLER_44_637 VGND VGND VPWR VPWR sky130_fd_sc_hd__decap_6
XFILLER_101_51 VGND VGND VPWR VPWR sky130_fd_sc_hd__decap_4
XFILLER_52_681 VGND VGND VPWR VPWR sky130_fd_sc_hd__decap_8
XFILLER_43_169 VPWR VGND VPWR VGND sky130_ef_sc_hd__decap_12
XTAP_TAPCELL_ROW_104_1498 VGND VPWR sky130_fd_sc_hd__tapvpwrvgnd_1
XFILLER_12_523 VGND VGND VPWR VPWR sky130_fd_sc_hd__decap_8
XFILLER_12_589 VPWR VGND VPWR VGND sky130_ef_sc_hd__decap_12
XFILLER_12_567 VPWR VGND VPWR VGND sky130_ef_sc_hd__decap_12
XFILLER_113_609 VGND VGND VPWR VPWR sky130_fd_sc_hd__decap_6
XFILLER_79_523 VGND VGND VPWR VPWR sky130_fd_sc_hd__fill_2
XTAP_TAPCELL_ROW_72_1111 VGND VPWR sky130_fd_sc_hd__tapvpwrvgnd_1
XFILLER_3_276 VGND VGND VPWR VPWR sky130_fd_sc_hd__decap_4
XFILLER_94_526 VGND VGND VPWR VPWR sky130_fd_sc_hd__decap_6
XFILLER_86_52 VPWR VGND VPWR VGND sky130_ef_sc_hd__decap_12
XFILLER_86_85 VPWR VGND VPWR VGND sky130_ef_sc_hd__decap_12
XFILLER_19_111 VGND VGND VPWR VPWR sky130_fd_sc_hd__fill_1
XFILLER_74_261 VGND VGND VPWR VPWR sky130_fd_sc_hd__fill_1
XFILLER_62_401 VGND VGND VPWR VPWR sky130_fd_sc_hd__decap_8
XFILLER_34_136 VGND VGND VPWR VPWR sky130_fd_sc_hd__decap_4
XTAP_TAPCELL_ROW_83_1251 VGND VPWR sky130_fd_sc_hd__tapvpwrvgnd_1
XFILLER_62_489 VGND VGND VPWR VPWR sky130_fd_sc_hd__decap_3
XFILLER_15_361 VGND VGND VPWR VPWR sky130_fd_sc_hd__fill_1
XFILLER_22_309 VPWR VGND VPWR VGND sky130_ef_sc_hd__decap_12
X_4620_ _0261_ _0320_ _0381_ _0382_ VGND VGND VPWR VPWR _0383_ sky130_fd_sc_hd__or4bb_2
XFILLER_30_397 VGND VGND VPWR VPWR sky130_fd_sc_hd__fill_2
X_4551_ _0313_ _0314_ _2869_ VGND VGND VPWR VPWR _0315_ sky130_fd_sc_hd__a21o_1
XFILLER_116_447 VGND VGND VPWR VPWR sky130_fd_sc_hd__fill_1
X_4482_ _0242_ _0243_ _0244_ VGND VGND VPWR VPWR _0247_ sky130_fd_sc_hd__a21o_1
X_3502_ _1266_ _1528_ net118 _1812_ VGND VGND VPWR VPWR _1823_ sky130_fd_sc_hd__a22o_1
X_3433_ net67 net179 _1048_ VGND VGND VPWR VPWR _1070_ sky130_fd_sc_hd__or3_4
X_6221_ _2088_ VGND VGND VPWR VPWR _2089_ sky130_fd_sc_hd__inv_2
XTAP_TAPCELL_ROW_94_1380 VGND VPWR sky130_fd_sc_hd__tapvpwrvgnd_1
X_6152_ _1718_ _1858_ _1860_ VGND VGND VPWR VPWR _2014_ sky130_fd_sc_hd__a21oi_1
XFILLER_106_29 VPWR VGND VPWR VGND sky130_ef_sc_hd__decap_12
X_5103_ _0867_ _0868_ _0729_ VGND VGND VPWR VPWR _0870_ sky130_fd_sc_hd__a21o_1
XFILLER_111_152 VPWR VGND VPWR VGND sky130_ef_sc_hd__decap_12
X_6083_ _1752_ _1936_ _1937_ VGND VGND VPWR VPWR _1938_ sky130_fd_sc_hd__and3_1
X_5034_ net365 net194 VGND VGND VPWR VPWR _0794_ sky130_fd_sc_hd__nand2_1
XTAP_TAPCELL_ROW_56_919 VGND VPWR sky130_fd_sc_hd__tapvpwrvgnd_1
XFILLER_93_581 VPWR VGND VPWR VGND sky130_ef_sc_hd__decap_12
XTAP_TAPCELL_ROW_0_235 VGND VPWR sky130_fd_sc_hd__tapvpwrvgnd_1
XFILLER_26_637 VGND VGND VPWR VPWR sky130_fd_sc_hd__decap_6
XFILLER_38_475 VGND VGND VPWR VPWR sky130_fd_sc_hd__fill_1
XFILLER_38_497 VGND VGND VPWR VPWR sky130_fd_sc_hd__fill_2
XFILLER_80_231 VGND VGND VPWR VPWR sky130_fd_sc_hd__fill_1
XFILLER_65_294 VPWR VGND VPWR VGND sky130_ef_sc_hd__decap_12
XTAP_TAPCELL_ROW_0_246 VGND VPWR sky130_fd_sc_hd__tapvpwrvgnd_1
XTAP_TAPCELL_ROW_0_257 VGND VPWR sky130_fd_sc_hd__tapvpwrvgnd_1
X_5936_ net383 net319 _1775_ _1776_ VGND VGND VPWR VPWR _1778_ sky130_fd_sc_hd__a22o_1
XFILLER_13_309 VGND VGND VPWR VPWR sky130_fd_sc_hd__decap_3
XFILLER_15_15 VPWR VGND VPWR VGND sky130_ef_sc_hd__decap_12
XFILLER_25_169 VGND VGND VPWR VPWR sky130_fd_sc_hd__fill_1
XTAP_TAPCELL_ROW_36_687 VGND VPWR sky130_fd_sc_hd__tapvpwrvgnd_1
XFILLER_41_629 VPWR VGND VPWR VGND sky130_ef_sc_hd__decap_12
XFILLER_80_286 VPWR VGND VPWR VGND sky130_ef_sc_hd__decap_12
XFILLER_34_681 VGND VGND VPWR VPWR sky130_fd_sc_hd__decap_8
XFILLER_33_191 VPWR VGND VPWR VGND sky130_ef_sc_hd__decap_12
X_5867_ _1656_ _1657_ _1701_ _1702_ VGND VGND VPWR VPWR _1704_ sky130_fd_sc_hd__nor4_1
X_4818_ _0512_ _0514_ VGND VGND VPWR VPWR _0578_ sky130_fd_sc_hd__nand2_1
X_5798_ _1625_ _1627_ VGND VGND VPWR VPWR _1628_ sky130_fd_sc_hd__nand2b_1
X_4749_ net372 net216 _0508_ _0509_ VGND VGND VPWR VPWR _0510_ sky130_fd_sc_hd__a22o_1
XFILLER_107_447 VGND VGND VPWR VPWR sky130_fd_sc_hd__fill_1
XFILLER_31_69 VPWR VGND VPWR VGND sky130_ef_sc_hd__decap_12
X_6419_ _2302_ _2304_ _2103_ _2105_ VGND VGND VPWR VPWR _2306_ sky130_fd_sc_hd__a211o_1
XFILLER_103_653 VPWR VGND VPWR VGND sky130_ef_sc_hd__decap_12
XTAP_TAPCELL_ROW_8_346 VGND VPWR sky130_fd_sc_hd__tapvpwrvgnd_1
XFILLER_0_246 VGND VGND VPWR VPWR sky130_fd_sc_hd__decap_6
XFILLER_102_141 VPWR VGND VPWR VGND sky130_ef_sc_hd__decap_12
XFILLER_76_504 VGND VGND VPWR VPWR sky130_fd_sc_hd__decap_8
XFILLER_48_206 VPWR VGND VPWR VGND sky130_ef_sc_hd__decap_12
XTAP_TAPCELL_ROW_106_1527 VGND VPWR sky130_fd_sc_hd__tapvpwrvgnd_1
XFILLER_84_570 VPWR VGND VPWR VGND sky130_ef_sc_hd__decap_12
XFILLER_16_103 VPWR VGND VPWR VGND sky130_ef_sc_hd__decap_12
XFILLER_44_401 VPWR VGND VPWR VGND sky130_ef_sc_hd__decap_12
XFILLER_71_220 VGND VGND VPWR VPWR sky130_fd_sc_hd__decap_4
XFILLER_44_445 VPWR VGND VPWR VGND sky130_ef_sc_hd__decap_12
XFILLER_112_83 VGND VGND VPWR VPWR sky130_fd_sc_hd__fill_1
XFILLER_24_180 VGND VGND VPWR VPWR sky130_fd_sc_hd__decap_6
XFILLER_12_331 VPWR VGND VPWR VGND sky130_ef_sc_hd__decap_12
XFILLER_8_324 VGND VGND VPWR VPWR sky130_fd_sc_hd__fill_2
XFILLER_113_428 VPWR VGND VPWR VGND sky130_ef_sc_hd__decap_12
XFILLER_99_629 VPWR VGND VPWR VGND sky130_ef_sc_hd__decap_12
XFILLER_97_51 VGND VGND VPWR VPWR sky130_fd_sc_hd__decap_4
XFILLER_39_239 VGND VGND VPWR VPWR sky130_fd_sc_hd__fill_1
XFILLER_35_412 VPWR VGND VPWR VGND sky130_ef_sc_hd__decap_12
XFILLER_47_272 VGND VGND VPWR VPWR sky130_fd_sc_hd__decap_8
XFILLER_90_551 VPWR VGND VPWR VGND sky130_ef_sc_hd__decap_12
XFILLER_90_573 VPWR VGND VPWR VGND sky130_ef_sc_hd__decap_12
XFILLER_62_275 VGND VGND VPWR VPWR sky130_fd_sc_hd__fill_1
XFILLER_62_253 VGND VGND VPWR VPWR sky130_fd_sc_hd__fill_1
XFILLER_23_629 VPWR VGND VPWR VGND sky130_ef_sc_hd__decap_12
X_6770_ net435 net213 VGND VGND VPWR VPWR _2688_ sky130_fd_sc_hd__nand2_1
X_3982_ _3162_ _3169_ VGND VGND VPWR VPWR _3171_ sky130_fd_sc_hd__or2_1
XFILLER_16_681 VGND VGND VPWR VPWR sky130_fd_sc_hd__decap_8
XFILLER_22_139 VGND VGND VPWR VPWR sky130_fd_sc_hd__fill_1
XTAP_TAPCELL_ROW_33_646 VGND VPWR sky130_fd_sc_hd__tapvpwrvgnd_1
X_5721_ _1358_ _1360_ VGND VGND VPWR VPWR _1544_ sky130_fd_sc_hd__nand2_1
XPHY_EDGE_ROW_99_Left_216 VGND VGND VPWR VPWR sky130_fd_sc_hd__decap_3
XTAP_TAPCELL_ROW_61_988 VGND VPWR sky130_fd_sc_hd__tapvpwrvgnd_1
X_5652_ net420 net275 _1380_ _1260_ net269 VGND VGND VPWR VPWR _1468_ sky130_fd_sc_hd__a32o_1
XFILLER_31_673 VPWR VGND VPWR VGND sky130_ef_sc_hd__decap_12
X_4603_ _0354_ _0364_ _0365_ VGND VGND VPWR VPWR _0366_ sky130_fd_sc_hd__nand3_2
X_5583_ _1385_ _1391_ VGND VGND VPWR VPWR _1393_ sky130_fd_sc_hd__xnor2_1
X_4534_ net242 net229 net392 net377 VGND VGND VPWR VPWR _0298_ sky130_fd_sc_hd__nand4_1
X_4465_ _0229_ _0230_ VGND VGND VPWR VPWR _0231_ sky130_fd_sc_hd__nand2b_1
XFILLER_89_117 VGND VGND VPWR VPWR sky130_fd_sc_hd__fill_1
X_4396_ net225 net414 net406 net238 VGND VGND VPWR VPWR _0163_ sky130_fd_sc_hd__a22o_1
X_6204_ _2068_ _2069_ net461 net193 VGND VGND VPWR VPWR _2070_ sky130_fd_sc_hd__and4bb_1
X_3416_ net435 VGND VGND VPWR VPWR _0885_ sky130_fd_sc_hd__inv_2
XFILLER_100_601 VPWR VGND VPWR VGND sky130_ef_sc_hd__decap_12
XFILLER_97_161 VGND VGND VPWR VPWR sky130_fd_sc_hd__decap_6
XTAP_TAPCELL_ROW_5_316 VGND VPWR sky130_fd_sc_hd__tapvpwrvgnd_1
X_6135_ _1835_ _1839_ _1992_ _1994_ VGND VGND VPWR VPWR _1995_ sky130_fd_sc_hd__a211oi_1
XFILLER_100_645 VPWR VGND VPWR VGND sky130_ef_sc_hd__decap_12
X_6066_ _1775_ _1777_ VGND VGND VPWR VPWR _1919_ sky130_fd_sc_hd__nand2_1
X_5017_ _0684_ _0774_ _0775_ VGND VGND VPWR VPWR _0777_ sky130_fd_sc_hd__and3_1
XFILLER_100_689 VGND VGND VPWR VPWR sky130_fd_sc_hd__decap_3
XFILLER_38_294 VPWR VGND VPWR VGND sky130_ef_sc_hd__decap_12
XFILLER_53_231 VGND VGND VPWR VPWR sky130_fd_sc_hd__fill_1
XFILLER_81_551 VGND VGND VPWR VPWR sky130_fd_sc_hd__decap_4
XFILLER_26_467 VGND VGND VPWR VPWR sky130_fd_sc_hd__decap_8
XFILLER_26_489 VGND VGND VPWR VPWR sky130_fd_sc_hd__decap_8
XFILLER_53_253 VPWR VGND VPWR VGND sky130_ef_sc_hd__decap_12
X_6899_ net182 _alu_i0.Datapath_i.fu_alu_33673_33851.out1\[25\] VGND VGND VPWR VPWR
+ _alu_i0.Datapath_i.reg_0.reg_out1\[25\] sky130_fd_sc_hd__dfxtp_1
X_5919_ net172 net186 net341 net178 VGND VGND VPWR VPWR _1760_ sky130_fd_sc_hd__a22o_1
XTAP_TAPCELL_ROW_101_1468 VGND VPWR sky130_fd_sc_hd__tapvpwrvgnd_1
XFILLER_101_3 VPWR VGND VPWR VGND sky130_ef_sc_hd__decap_12
XFILLER_89_673 VPWR VGND VPWR VGND sky130_ef_sc_hd__decap_12
XTAP_TAPCELL_ROW_112_1597 VGND VPWR sky130_fd_sc_hd__tapvpwrvgnd_1
XFILLER_88_194 VGND VGND VPWR VPWR sky130_fd_sc_hd__fill_2
XFILLER_88_161 VPWR VGND VPWR VGND sky130_ef_sc_hd__decap_12
XFILLER_76_345 VPWR VGND VPWR VGND sky130_ef_sc_hd__decap_12
XFILLER_49_559 VGND VGND VPWR VPWR sky130_fd_sc_hd__fill_1
XFILLER_91_315 VGND VGND VPWR VPWR sky130_fd_sc_hd__decap_4
XFILLER_36_209 VGND VGND VPWR VPWR sky130_fd_sc_hd__decap_4
XFILLER_91_337 VGND VGND VPWR VPWR sky130_fd_sc_hd__decap_4
XTAP_TAPCELL_ROW_67_1054 VGND VPWR sky130_fd_sc_hd__tapvpwrvgnd_1
XFILLER_44_253 VPWR VGND VPWR VGND sky130_ef_sc_hd__decap_12
XTAP_TAPCELL_ROW_80_1210 VGND VPWR sky130_fd_sc_hd__tapvpwrvgnd_1
XFILLER_16_91 VPWR VGND VPWR VGND sky130_ef_sc_hd__decap_12
XFILLER_13_673 VPWR VGND VPWR VGND sky130_ef_sc_hd__decap_12
XTAP_TAPCELL_ROW_30_616 VGND VPWR sky130_fd_sc_hd__tapvpwrvgnd_1
XTAP_TAPCELL_ROW_10_373 VGND VPWR sky130_fd_sc_hd__tapvpwrvgnd_1
XFILLER_99_404 VGND VGND VPWR VPWR sky130_fd_sc_hd__fill_2
XTAP_TAPCELL_ROW_78_1183 VGND VPWR sky130_fd_sc_hd__tapvpwrvgnd_1
XFILLER_113_225 VGND VGND VPWR VPWR sky130_fd_sc_hd__decap_6
X_4250_ net157 _3261_ _0025_ net120 VGND VGND VPWR VPWR _0026_ sky130_fd_sc_hd__o211a_1
XFILLER_4_393 VGND VGND VPWR VPWR sky130_fd_sc_hd__fill_2
X_4181_ net138 _3352_ _3356_ _3360_ net131 VGND VGND VPWR VPWR _3361_ sky130_fd_sc_hd__a221oi_1
XFILLER_95_665 VGND VGND VPWR VPWR sky130_fd_sc_hd__decap_6
XFILLER_67_378 VGND VGND VPWR VPWR sky130_fd_sc_hd__decap_8
XFILLER_55_529 VPWR VGND VPWR VGND sky130_ef_sc_hd__decap_12
XTAP_TAPCELL_ROW_38_705 VGND VPWR sky130_fd_sc_hd__tapvpwrvgnd_1
XFILLER_63_540 VGND VGND VPWR VPWR sky130_fd_sc_hd__fill_1
XFILLER_35_220 VGND VGND VPWR VPWR sky130_fd_sc_hd__decap_4
X_6822_ _2504_ _2742_ VGND VGND VPWR VPWR _2745_ sky130_fd_sc_hd__xnor2_1
XFILLER_35_253 VGND VGND VPWR VPWR sky130_fd_sc_hd__decap_6
XTAP_TAPCELL_ROW_18_462 VGND VPWR sky130_fd_sc_hd__tapvpwrvgnd_1
XTAP_TAPCELL_ROW_18_473 VGND VPWR sky130_fd_sc_hd__tapvpwrvgnd_1
XFILLER_50_201 VGND VGND VPWR VPWR sky130_fd_sc_hd__fill_1
X_3965_ _3065_ _3154_ net159 VGND VGND VPWR VPWR _3155_ sky130_fd_sc_hd__mux2_1
X_6753_ _2645_ _2646_ _2649_ VGND VGND VPWR VPWR _2669_ sky130_fd_sc_hd__a21oi_1
X_3896_ net151 _3087_ _3088_ VGND VGND VPWR VPWR _3089_ sky130_fd_sc_hd__a21bo_1
X_6684_ _2556_ _2593_ VGND VGND VPWR VPWR _2594_ sky130_fd_sc_hd__xnor2_1
X_5704_ _1434_ _1523_ _1524_ VGND VGND VPWR VPWR _1525_ sky130_fd_sc_hd__or3_2
XFILLER_50_278 VGND VGND VPWR VPWR sky130_fd_sc_hd__decap_8
X_5635_ _1227_ _1229_ _1446_ _1448_ VGND VGND VPWR VPWR _1450_ sky130_fd_sc_hd__a211o_1
XFILLER_12_27 VGND VGND VPWR VPWR sky130_fd_sc_hd__fill_1
X_5566_ _1352_ _1371_ _1372_ VGND VGND VPWR VPWR _1374_ sky130_fd_sc_hd__nand3_2
X_4517_ _0280_ _0281_ _0224_ _0226_ VGND VGND VPWR VPWR _0282_ sky130_fd_sc_hd__a211oi_1
X_5497_ _1294_ _1297_ _1298_ VGND VGND VPWR VPWR _1300_ sky130_fd_sc_hd__and3_1
X_4448_ net358 net370 _0211_ _0212_ VGND VGND VPWR VPWR _0214_ sky130_fd_sc_hd__a22o_1
X_4379_ _0112_ _0146_ VGND VGND VPWR VPWR _0147_ sky130_fd_sc_hd__nor2_1
XFILLER_86_643 VGND VGND VPWR VPWR sky130_fd_sc_hd__fill_1
X_6118_ _1970_ _1974_ _1976_ VGND VGND VPWR VPWR _1977_ sky130_fd_sc_hd__nand3_2
XFILLER_100_475 VGND VGND VPWR VPWR sky130_fd_sc_hd__fill_1
XFILLER_58_389 VPWR VGND VPWR VGND sky130_ef_sc_hd__decap_12
X_6049_ _1754_ _1899_ _1900_ VGND VGND VPWR VPWR _1901_ sky130_fd_sc_hd__nor3_2
XFILLER_18_209 VGND VGND VPWR VPWR sky130_fd_sc_hd__fill_2
XFILLER_37_57 VGND VGND VPWR VPWR sky130_fd_sc_hd__decap_4
XFILLER_100_497 VGND VGND VPWR VPWR sky130_fd_sc_hd__decap_8
XFILLER_73_337 VGND VGND VPWR VPWR sky130_fd_sc_hd__decap_4
XFILLER_54_540 VPWR VGND VPWR VGND sky130_ef_sc_hd__decap_12
XFILLER_37_68 VPWR VGND VPWR VGND sky130_ef_sc_hd__decap_12
XFILLER_41_223 VGND VGND VPWR VPWR sky130_fd_sc_hd__fill_1
XFILLER_22_470 VGND VGND VPWR VPWR sky130_fd_sc_hd__decap_6
XFILLER_10_643 VGND VGND VPWR VPWR sky130_fd_sc_hd__fill_1
XFILLER_6_625 VPWR VGND VPWR VGND sky130_ef_sc_hd__decap_12
XFILLER_5_113 VPWR VGND VPWR VGND sky130_ef_sc_hd__decap_12
XFILLER_6_669 VPWR VGND VPWR VGND sky130_ef_sc_hd__decap_12
XTAP_TAPCELL_ROW_114_1615 VGND VPWR sky130_fd_sc_hd__tapvpwrvgnd_1
XFILLER_49_312 VGND VGND VPWR VPWR sky130_fd_sc_hd__decap_6
XFILLER_77_665 VGND VGND VPWR VPWR sky130_fd_sc_hd__decap_6
XFILLER_49_334 VGND VGND VPWR VPWR sky130_fd_sc_hd__fill_2
XFILLER_94_41 VPWR VGND VPWR VGND sky130_ef_sc_hd__decap_12
XFILLER_92_613 VPWR VGND VPWR VGND sky130_ef_sc_hd__decap_12
XFILLER_76_153 VPWR VGND VPWR VGND sky130_ef_sc_hd__decap_12
XFILLER_64_304 VGND VGND VPWR VPWR sky130_fd_sc_hd__decap_4
XFILLER_49_378 VGND VGND VPWR VPWR sky130_fd_sc_hd__fill_1
XFILLER_94_85 VGND VGND VPWR VPWR sky130_fd_sc_hd__decap_4
XFILLER_92_657 VPWR VGND VPWR VGND sky130_ef_sc_hd__decap_12
XFILLER_76_197 VGND VGND VPWR VPWR sky130_fd_sc_hd__decap_4
XFILLER_76_186 VGND VGND VPWR VPWR sky130_fd_sc_hd__decap_8
XFILLER_91_167 VGND VGND VPWR VPWR sky130_fd_sc_hd__fill_1
XFILLER_45_540 VGND VGND VPWR VPWR sky130_fd_sc_hd__fill_1
XFILLER_45_551 VGND VGND VPWR VPWR sky130_fd_sc_hd__decap_8
XFILLER_72_381 VGND VGND VPWR VPWR sky130_fd_sc_hd__fill_2
XFILLER_17_275 VGND VGND VPWR VPWR sky130_fd_sc_hd__decap_4
XFILLER_17_297 VPWR VGND VPWR VGND sky130_ef_sc_hd__decap_12
XTAP_TAPCELL_ROW_15_432 VGND VPWR sky130_fd_sc_hd__tapvpwrvgnd_1
X_3750_ net201 net377 VGND VGND VPWR VPWR _2949_ sky130_fd_sc_hd__and2b_1
XTAP_TAPCELL_ROW_43_763 VGND VPWR sky130_fd_sc_hd__tapvpwrvgnd_1
XFILLER_13_492 VGND VGND VPWR VPWR sky130_fd_sc_hd__fill_1
X_3681_ _2881_ _2882_ net232 VGND VGND VPWR VPWR _2883_ sky130_fd_sc_hd__mux2_1
XFILLER_9_485 VPWR VGND VPWR VGND sky130_ef_sc_hd__decap_12
X_5420_ net223 net169 net467 net235 VGND VGND VPWR VPWR _1215_ sky130_fd_sc_hd__a22o_1
XFILLER_114_501 VPWR VGND VPWR VGND sky130_ef_sc_hd__decap_12
X_5351_ _1075_ _1138_ _1139_ VGND VGND VPWR VPWR _1140_ sky130_fd_sc_hd__and3_1
XFILLER_114_545 VPWR VGND VPWR VGND sky130_ef_sc_hd__decap_12
X_4302_ net471 net238 net225 net454 VGND VGND VPWR VPWR _0072_ sky130_fd_sc_hd__and4_1
XFILLER_5_691 VGND VGND VPWR VPWR sky130_fd_sc_hd__fill_1
X_5282_ net396 net320 VGND VGND VPWR VPWR _1065_ sky130_fd_sc_hd__nand2_1
X_4233_ net24 net56 VGND VGND VPWR VPWR _0009_ sky130_fd_sc_hd__xnor2_4
XFILLER_114_589 VPWR VGND VPWR VGND sky130_ef_sc_hd__decap_12
XFILLER_101_206 VGND VGND VPWR VPWR sky130_fd_sc_hd__decap_8
XFILLER_68_621 VPWR VGND VPWR VGND sky130_ef_sc_hd__decap_12
XFILLER_4_83 VGND VGND VPWR VPWR sky130_fd_sc_hd__fill_1
XFILLER_114_29 VPWR VGND VPWR VGND sky130_ef_sc_hd__decap_12
X_4164_ net161 _3344_ net234 VGND VGND VPWR VPWR _3345_ sky130_fd_sc_hd__a21o_1
X_4095_ _3193_ _3278_ net158 VGND VGND VPWR VPWR _3279_ sky130_fd_sc_hd__mux2_1
XFILLER_55_326 VGND VGND VPWR VPWR sky130_fd_sc_hd__decap_8
XFILLER_70_329 VPWR VGND VPWR VGND sky130_ef_sc_hd__decap_12
XFILLER_51_532 VGND VGND VPWR VPWR sky130_fd_sc_hd__decap_8
X_6805_ _2724_ _2725_ VGND VGND VPWR VPWR _2726_ sky130_fd_sc_hd__nand2b_1
X_4997_ _0750_ _0753_ _0754_ VGND VGND VPWR VPWR _0755_ sky130_fd_sc_hd__nand3_2
X_6736_ _2481_ _2483_ _2650_ VGND VGND VPWR VPWR _2651_ sky130_fd_sc_hd__o21a_1
XFILLER_23_15 VPWR VGND VPWR VGND sky130_ef_sc_hd__decap_12
X_3948_ net236 _2957_ VGND VGND VPWR VPWR _3139_ sky130_fd_sc_hd__nand2_1
XFILLER_109_317 VPWR VGND VPWR VGND sky130_ef_sc_hd__decap_12
X_3879_ net218 net319 VGND VGND VPWR VPWR _3072_ sky130_fd_sc_hd__nand2_2
X_6667_ net175 net316 net306 net220 VGND VGND VPWR VPWR _2576_ sky130_fd_sc_hd__a22o_1
X_6598_ _2497_ _2499_ VGND VGND VPWR VPWR _2500_ sky130_fd_sc_hd__xnor2_1
X_5618_ _1305_ _1307_ _1429_ _1431_ VGND VGND VPWR VPWR _1432_ sky130_fd_sc_hd__a211oi_2
XFILLER_105_512 VPWR VGND VPWR VGND sky130_ef_sc_hd__decap_12
XFILLER_3_617 VPWR VGND VPWR VGND sky130_ef_sc_hd__decap_12
X_5549_ _1274_ _1278_ _1275_ VGND VGND VPWR VPWR _1356_ sky130_fd_sc_hd__o21bai_1
Xfanout431 net432 VGND VGND VPWR VPWR net431 sky130_fd_sc_hd__clkbuf_4
Xfanout420 net421 VGND VGND VPWR VPWR net420 sky130_fd_sc_hd__clkbuf_4
Xfanout475 net1 VGND VGND VPWR VPWR net475 sky130_fd_sc_hd__clkbuf_4
XFILLER_59_665 VGND VGND VPWR VPWR sky130_fd_sc_hd__decap_6
Xfanout453 net459 VGND VGND VPWR VPWR net453 sky130_fd_sc_hd__clkbuf_4
Xfanout442 net444 VGND VGND VPWR VPWR net442 sky130_fd_sc_hd__buf_2
Xfanout464 net465 VGND VGND VPWR VPWR net464 sky130_fd_sc_hd__buf_2
XFILLER_58_153 VPWR VGND VPWR VGND sky130_ef_sc_hd__decap_12
XFILLER_100_283 VPWR VGND VPWR VGND sky130_ef_sc_hd__decap_12
XFILLER_74_657 VPWR VGND VPWR VGND sky130_ef_sc_hd__decap_12
XFILLER_58_197 VGND VGND VPWR VPWR sky130_fd_sc_hd__fill_1
XFILLER_58_186 VGND VGND VPWR VPWR sky130_fd_sc_hd__fill_2
XFILLER_46_326 VPWR VGND VPWR VGND sky130_ef_sc_hd__decap_12
XTAP_TAPCELL_ROW_64_1024 VGND VPWR sky130_fd_sc_hd__tapvpwrvgnd_1
XFILLER_64_77 VGND VGND VPWR VPWR sky130_fd_sc_hd__fill_1
XFILLER_27_584 VPWR VGND VPWR VGND sky130_ef_sc_hd__decap_12
XFILLER_14_234 VGND VGND VPWR VPWR sky130_fd_sc_hd__fill_1
XFILLER_14_256 VPWR VGND VPWR VGND sky130_ef_sc_hd__decap_12
XFILLER_9_39 VPWR VGND VPWR VGND sky130_ef_sc_hd__decap_12
XTAP_TAPCELL_ROW_40_733 VGND VPWR sky130_fd_sc_hd__tapvpwrvgnd_1
XTAP_TAPCELL_ROW_20_490 VGND VPWR sky130_fd_sc_hd__tapvpwrvgnd_1
XFILLER_50_9 VPWR VGND VPWR VGND sky130_ef_sc_hd__decap_12
XFILLER_108_394 VGND VGND VPWR VPWR sky130_fd_sc_hd__fill_1
XTAP_TAPCELL_ROW_75_1153 VGND VPWR sky130_fd_sc_hd__tapvpwrvgnd_1
XFILLER_111_559 VGND VGND VPWR VPWR sky130_fd_sc_hd__fill_1
XFILLER_77_473 VPWR VGND VPWR VGND sky130_ef_sc_hd__decap_12
XFILLER_49_153 VGND VGND VPWR VPWR sky130_fd_sc_hd__decap_8
XFILLER_37_337 VPWR VGND VPWR VGND sky130_ef_sc_hd__decap_12
XTAP_TAPCELL_ROW_48_822 VGND VPWR sky130_fd_sc_hd__tapvpwrvgnd_1
XTAP_TAPCELL_ROW_48_833 VGND VPWR sky130_fd_sc_hd__tapvpwrvgnd_1
XFILLER_52_307 VGND VGND VPWR VPWR sky130_fd_sc_hd__fill_1
X_4920_ _0678_ VGND VGND VPWR VPWR _0679_ sky130_fd_sc_hd__inv_2
XTAP_TAPCELL_ROW_86_1282 VGND VPWR sky130_fd_sc_hd__tapvpwrvgnd_1
X_4851_ _0501_ _0503_ _0609_ _0610_ VGND VGND VPWR VPWR _0611_ sky130_fd_sc_hd__o211ai_4
XTAP_TAPCELL_ROW_28_590 VGND VPWR sky130_fd_sc_hd__tapvpwrvgnd_1
X_3802_ _2520_ _2597_ net155 VGND VGND VPWR VPWR _2999_ sky130_fd_sc_hd__mux2_1
X_4782_ _alu_i0.Datapath_i.reg_0.reg_out1\[13\] _0542_ net146 VGND VGND VPWR VPWR
+ net81 sky130_fd_sc_hd__mux2_1
XPHY_EDGE_ROW_72_Left_189 VGND VGND VPWR VPWR sky130_fd_sc_hd__decap_3
X_3733_ net244 _2824_ VGND VGND VPWR VPWR _2933_ sky130_fd_sc_hd__nor2_2
X_6521_ _2415_ _2416_ VGND VGND VPWR VPWR _2417_ sky130_fd_sc_hd__xnor2_1
X_3664_ net154 _2864_ _2866_ net118 VGND VGND VPWR VPWR _2867_ sky130_fd_sc_hd__o211a_1
X_6452_ _2334_ _2340_ VGND VGND VPWR VPWR _2341_ sky130_fd_sc_hd__nand2b_1
XFILLER_106_309 VPWR VGND VPWR VGND sky130_ef_sc_hd__decap_12
X_5403_ _1079_ _1083_ _1195_ _1196_ VGND VGND VPWR VPWR _1197_ sky130_fd_sc_hd__a211o_2
XFILLER_114_320 VGND VGND VPWR VPWR sky130_fd_sc_hd__fill_2
X_3595_ _2739_ _2799_ VGND VGND VPWR VPWR _2800_ sky130_fd_sc_hd__nor2_1
X_6383_ net222 net438 net436 net234 VGND VGND VPWR VPWR _2266_ sky130_fd_sc_hd__a22oi_1
X_5334_ net262 net221 net207 net200 VGND VGND VPWR VPWR _1121_ sky130_fd_sc_hd__nand4_2
XPHY_EDGE_ROW_81_Left_198 VGND VGND VPWR VPWR sky130_fd_sc_hd__decap_3
X_5265_ _2963_ _2981_ _1045_ VGND VGND VPWR VPWR _1046_ sky130_fd_sc_hd__a21bo_1
XFILLER_102_548 VPWR VGND VPWR VGND sky130_ef_sc_hd__decap_12
X_5196_ _0940_ _0969_ VGND VGND VPWR VPWR _0971_ sky130_fd_sc_hd__xnor2_1
X_4216_ _3371_ _3372_ _3370_ VGND VGND VPWR VPWR _3394_ sky130_fd_sc_hd__o21bai_1
X_4147_ net151 _3155_ _3328_ net120 VGND VGND VPWR VPWR _3329_ sky130_fd_sc_hd__o211a_1
XFILLER_18_15 VPWR VGND VPWR VGND sky130_ef_sc_hd__decap_12
XFILLER_110_581 VGND VGND VPWR VPWR sky130_fd_sc_hd__decap_6
XFILLER_95_292 VGND VGND VPWR VPWR sky130_fd_sc_hd__fill_2
XFILLER_83_432 VPWR VGND VPWR VGND sky130_ef_sc_hd__decap_12
XFILLER_56_657 VPWR VGND VPWR VGND sky130_ef_sc_hd__decap_12
XFILLER_83_465 VPWR VGND VPWR VGND sky130_ef_sc_hd__decap_12
X_4078_ _2914_ _3135_ VGND VGND VPWR VPWR _3263_ sky130_fd_sc_hd__or2_1
XFILLER_55_156 VPWR VGND VPWR VGND sky130_ef_sc_hd__decap_12
XFILLER_83_498 VGND VGND VPWR VPWR sky130_fd_sc_hd__decap_6
XFILLER_70_115 VPWR VGND VPWR VGND sky130_ef_sc_hd__decap_12
XFILLER_55_178 VPWR VGND VPWR VGND sky130_ef_sc_hd__decap_12
X_6719_ _2631_ _2632_ VGND VGND VPWR VPWR _2633_ sky130_fd_sc_hd__nand2_1
XFILLER_109_169 VPWR VGND VPWR VGND sky130_ef_sc_hd__decap_12
XFILLER_109_158 VGND VGND VPWR VPWR sky130_fd_sc_hd__decap_8
XFILLER_3_447 VGND VGND VPWR VPWR sky130_fd_sc_hd__fill_1
XFILLER_105_397 VGND VGND VPWR VPWR sky130_fd_sc_hd__decap_4
Xfanout250 net55 VGND VGND VPWR VPWR net250 sky130_fd_sc_hd__clkbuf_4
Xfanout283 net44 VGND VGND VPWR VPWR net283 sky130_fd_sc_hd__buf_2
Xfanout261 net262 VGND VGND VPWR VPWR net261 sky130_fd_sc_hd__buf_2
Xfanout272 net273 VGND VGND VPWR VPWR net272 sky130_fd_sc_hd__buf_2
XFILLER_47_602 VGND VGND VPWR VPWR sky130_fd_sc_hd__fill_1
XFILLER_75_43 VGND VGND VPWR VPWR sky130_fd_sc_hd__decap_6
XTAP_TAPCELL_ROW_70_1094 VGND VPWR sky130_fd_sc_hd__tapvpwrvgnd_1
Xfanout294 net295 VGND VGND VPWR VPWR net294 sky130_fd_sc_hd__buf_2
XFILLER_19_337 VGND VGND VPWR VPWR sky130_fd_sc_hd__decap_8
XTAP_TAPCELL_ROW_109_1558 VGND VPWR sky130_fd_sc_hd__tapvpwrvgnd_1
XFILLER_34_307 VGND VGND VPWR VPWR sky130_fd_sc_hd__fill_1
XFILLER_61_126 VGND VGND VPWR VPWR sky130_fd_sc_hd__fill_1
XFILLER_46_189 VGND VGND VPWR VPWR sky130_fd_sc_hd__decap_6
XFILLER_61_159 VGND VGND VPWR VPWR sky130_fd_sc_hd__decap_8
XFILLER_27_381 VGND VGND VPWR VPWR sky130_fd_sc_hd__decap_8
XFILLER_91_75 VGND VGND VPWR VPWR sky130_fd_sc_hd__fill_1
XFILLER_91_53 VGND VGND VPWR VPWR sky130_fd_sc_hd__decap_3
XFILLER_30_502 VPWR VGND VPWR VGND sky130_ef_sc_hd__decap_12
XTAP_TAPCELL_ROW_53_891 VGND VPWR sky130_fd_sc_hd__tapvpwrvgnd_1
XFILLER_6_285 VGND VGND VPWR VPWR sky130_fd_sc_hd__decap_6
XFILLER_97_513 VGND VGND VPWR VPWR sky130_fd_sc_hd__decap_6
XFILLER_97_557 VGND VGND VPWR VPWR sky130_fd_sc_hd__decap_3
X_5050_ net425 net317 net308 net457 VGND VGND VPWR VPWR _0812_ sky130_fd_sc_hd__a22oi_1
XFILLER_111_389 VGND VGND VPWR VPWR sky130_fd_sc_hd__decap_3
XFILLER_27_3 VPWR VGND VPWR VGND sky130_ef_sc_hd__decap_12
X_4001_ _3187_ _3188_ _3185_ VGND VGND VPWR VPWR _3189_ sky130_fd_sc_hd__mux2_1
XTAP_TAPCELL_ROW_88_1311 VGND VPWR sky130_fd_sc_hd__tapvpwrvgnd_1
XFILLER_77_281 VGND VGND VPWR VPWR sky130_fd_sc_hd__decap_4
XFILLER_92_251 VGND VGND VPWR VPWR sky130_fd_sc_hd__fill_1
XFILLER_92_240 VGND VGND VPWR VPWR sky130_fd_sc_hd__decap_6
XFILLER_1_51 VGND VGND VPWR VPWR sky130_fd_sc_hd__decap_4
XFILLER_38_657 VPWR VGND VPWR VGND sky130_ef_sc_hd__decap_12
XFILLER_92_284 VGND VGND VPWR VPWR sky130_fd_sc_hd__decap_6
X_5952_ _1791_ _1793_ _1644_ _1646_ VGND VGND VPWR VPWR _1796_ sky130_fd_sc_hd__o211a_1
X_4903_ _0583_ _0585_ VGND VGND VPWR VPWR _0662_ sky130_fd_sc_hd__nand2_1
XFILLER_61_671 VGND VGND VPWR VPWR sky130_fd_sc_hd__fill_1
X_5883_ _1454_ _1580_ _1581_ VGND VGND VPWR VPWR _1721_ sky130_fd_sc_hd__o21a_1
X_4834_ _0590_ _0591_ _0578_ VGND VGND VPWR VPWR _0594_ sky130_fd_sc_hd__a21oi_1
X_4765_ _0523_ _0524_ _0450_ _0453_ VGND VGND VPWR VPWR _0526_ sky130_fd_sc_hd__a211oi_1
XTAP_TAPCELL_ROW_99_1440 VGND VPWR sky130_fd_sc_hd__tapvpwrvgnd_1
X_3716_ net132 _2895_ _2914_ net121 _2916_ VGND VGND VPWR VPWR _2917_ sky130_fd_sc_hd__a221o_1
X_6504_ _2395_ _2396_ VGND VGND VPWR VPWR _2398_ sky130_fd_sc_hd__xnor2_1
X_4696_ _0455_ _0456_ _0418_ VGND VGND VPWR VPWR _0458_ sky130_fd_sc_hd__o21ai_1
XFILLER_107_629 VPWR VGND VPWR VGND sky130_ef_sc_hd__decap_12
XFILLER_106_139 VGND VGND VPWR VPWR sky130_fd_sc_hd__fill_1
XFILLER_106_128 VGND VGND VPWR VPWR sky130_fd_sc_hd__fill_1
X_3647_ _2809_ _2810_ _2805_ VGND VGND VPWR VPWR _2850_ sky130_fd_sc_hd__a21o_1
XFILLER_20_27 VGND VGND VPWR VPWR sky130_fd_sc_hd__fill_1
X_6435_ _2320_ _2321_ VGND VGND VPWR VPWR _2323_ sky130_fd_sc_hd__xnor2_1
X_3578_ _2641_ VGND VGND VPWR VPWR _2652_ sky130_fd_sc_hd__inv_2
X_6366_ _2038_ _2043_ _2246_ VGND VGND VPWR VPWR _2247_ sky130_fd_sc_hd__o21a_1
XFILLER_115_673 VPWR VGND VPWR VGND sky130_ef_sc_hd__decap_12
XFILLER_88_513 VGND VGND VPWR VPWR sky130_fd_sc_hd__decap_4
X_5317_ net282 net462 VGND VGND VPWR VPWR _1103_ sky130_fd_sc_hd__and2_1
X_6297_ _2170_ _2171_ VGND VGND VPWR VPWR _2173_ sky130_fd_sc_hd__xnor2_1
XFILLER_75_218 VGND VGND VPWR VPWR sky130_fd_sc_hd__decap_6
X_5248_ _0915_ _0919_ _1025_ _1027_ VGND VGND VPWR VPWR _1028_ sky130_fd_sc_hd__a211oi_4
XFILLER_29_69 VPWR VGND VPWR VGND sky130_ef_sc_hd__decap_12
XFILLER_29_602 VPWR VGND VPWR VGND sky130_ef_sc_hd__decap_12
XFILLER_75_229 VGND VGND VPWR VPWR sky130_fd_sc_hd__fill_1
X_5179_ _0949_ _0951_ _0952_ VGND VGND VPWR VPWR _0953_ sky130_fd_sc_hd__and3_1
XFILLER_68_270 VGND VGND VPWR VPWR sky130_fd_sc_hd__decap_6
XFILLER_83_284 VPWR VGND VPWR VGND sky130_ef_sc_hd__decap_12
XTAP_TAPCELL_ROW_3_288 VGND VPWR sky130_fd_sc_hd__tapvpwrvgnd_1
XFILLER_16_307 VGND VGND VPWR VPWR sky130_fd_sc_hd__fill_1
XFILLER_28_189 VGND VGND VPWR VPWR sky130_fd_sc_hd__decap_6
XTAP_TAPCELL_ROW_104_1499 VGND VPWR sky130_fd_sc_hd__tapvpwrvgnd_1
XFILLER_12_579 VGND VGND VPWR VPWR sky130_fd_sc_hd__decap_8
XTAP_TAPCELL_ROW_50_850 VGND VPWR sky130_fd_sc_hd__tapvpwrvgnd_1
XFILLER_6_29 VPWR VGND VPWR VGND sky130_ef_sc_hd__decap_12
XFILLER_112_109 VPWR VGND VPWR VGND sky130_ef_sc_hd__decap_12
XFILLER_79_502 VGND VGND VPWR VPWR sky130_fd_sc_hd__fill_2
XTAP_TAPCELL_ROW_72_1112 VGND VPWR sky130_fd_sc_hd__tapvpwrvgnd_1
XFILLER_10_82 VGND VGND VPWR VPWR sky130_fd_sc_hd__fill_2
XFILLER_86_64 VPWR VGND VPWR VGND sky130_ef_sc_hd__decap_12
XFILLER_86_97 VGND VGND VPWR VPWR sky130_fd_sc_hd__fill_2
XFILLER_66_229 VGND VGND VPWR VPWR sky130_fd_sc_hd__fill_2
XFILLER_59_281 VGND VGND VPWR VPWR sky130_fd_sc_hd__fill_1
XFILLER_59_270 VGND VGND VPWR VPWR sky130_fd_sc_hd__decap_4
XTAP_TAPCELL_ROW_58_950 VGND VPWR sky130_fd_sc_hd__tapvpwrvgnd_1
XFILLER_47_443 VGND VGND VPWR VPWR sky130_fd_sc_hd__decap_4
XFILLER_74_251 VGND VGND VPWR VPWR sky130_fd_sc_hd__fill_1
XFILLER_19_167 VGND VGND VPWR VPWR sky130_fd_sc_hd__fill_1
XTAP_TAPCELL_ROW_83_1252 VGND VPWR sky130_fd_sc_hd__tapvpwrvgnd_1
XFILLER_43_671 VGND VGND VPWR VPWR sky130_fd_sc_hd__fill_1
XFILLER_30_321 VGND VGND VPWR VPWR sky130_fd_sc_hd__fill_2
XFILLER_42_170 VGND VGND VPWR VPWR sky130_fd_sc_hd__decap_8
XFILLER_30_365 VPWR VGND VPWR VGND sky130_ef_sc_hd__decap_12
X_4550_ net407 net208 net204 net415 VGND VGND VPWR VPWR _0314_ sky130_fd_sc_hd__a22o_1
X_4481_ _0242_ _0243_ _0244_ VGND VGND VPWR VPWR _0246_ sky130_fd_sc_hd__nand3_1
X_3501_ _1703_ _1801_ net155 VGND VGND VPWR VPWR _1812_ sky130_fd_sc_hd__mux2_1
XFILLER_7_561 VPWR VGND VPWR VGND sky130_ef_sc_hd__decap_12
X_3432_ net67 net179 _1048_ VGND VGND VPWR VPWR _1059_ sky130_fd_sc_hd__nor3_1
X_6220_ net382 net310 net314 net305 VGND VGND VPWR VPWR _2088_ sky130_fd_sc_hd__and4_1
XTAP_TAPCELL_ROW_94_1381 VGND VPWR sky130_fd_sc_hd__tapvpwrvgnd_1
X_6151_ _1719_ _1721_ _1723_ _1861_ VGND VGND VPWR VPWR _2013_ sky130_fd_sc_hd__or4b_2
XFILLER_112_643 VGND VGND VPWR VPWR sky130_fd_sc_hd__fill_1
XFILLER_106_19 VGND VGND VPWR VPWR sky130_fd_sc_hd__decap_8
X_5102_ _0729_ _0867_ _0868_ VGND VGND VPWR VPWR _0869_ sky130_fd_sc_hd__nand3_2
XFILLER_85_505 VPWR VGND VPWR VGND sky130_ef_sc_hd__decap_12
X_6082_ _1933_ _1935_ _1918_ VGND VGND VPWR VPWR _1937_ sky130_fd_sc_hd__o21ai_1
XFILLER_111_164 VGND VGND VPWR VPWR sky130_fd_sc_hd__decap_4
X_5033_ net469 net302 VGND VGND VPWR VPWR _0793_ sky130_fd_sc_hd__nand2_1
XFILLER_93_593 VPWR VGND VPWR VGND sky130_ef_sc_hd__decap_12
XTAP_TAPCELL_ROW_0_236 VGND VPWR sky130_fd_sc_hd__tapvpwrvgnd_1
XFILLER_80_210 VGND VGND VPWR VPWR sky130_fd_sc_hd__fill_1
XFILLER_53_435 VPWR VGND VPWR VGND sky130_ef_sc_hd__decap_12
XTAP_TAPCELL_ROW_0_247 VGND VPWR sky130_fd_sc_hd__tapvpwrvgnd_1
X_5935_ net383 net319 _1775_ _1776_ VGND VGND VPWR VPWR _1777_ sky130_fd_sc_hd__nand4_1
XFILLER_15_27 VPWR VGND VPWR VGND sky130_ef_sc_hd__decap_12
XFILLER_40_107 VGND VGND VPWR VPWR sky130_fd_sc_hd__decap_8
XFILLER_80_298 VGND VGND VPWR VPWR sky130_fd_sc_hd__decap_8
XFILLER_21_321 VGND VGND VPWR VPWR sky130_fd_sc_hd__fill_1
XFILLER_33_181 VGND VGND VPWR VPWR sky130_fd_sc_hd__decap_4
XTAP_TAPCELL_ROW_36_688 VGND VPWR sky130_fd_sc_hd__tapvpwrvgnd_1
X_5866_ _1699_ _1700_ _1559_ _1563_ VGND VGND VPWR VPWR _1702_ sky130_fd_sc_hd__o211a_1
X_4817_ _2314_ _0575_ VGND VGND VPWR VPWR _0577_ sky130_fd_sc_hd__xor2_1
X_5797_ _1622_ _1623_ _1624_ VGND VGND VPWR VPWR _1627_ sky130_fd_sc_hd__a21o_1
XFILLER_31_15 VPWR VGND VPWR VGND sky130_ef_sc_hd__decap_12
X_4748_ net379 net211 net203 net393 VGND VGND VPWR VPWR _0509_ sky130_fd_sc_hd__a22o_1
X_4679_ net379 net215 _0438_ _0439_ VGND VGND VPWR VPWR _0441_ sky130_fd_sc_hd__nand4_1
XPHY_EDGE_ROW_1_Right_1 VGND VGND VPWR VPWR sky130_fd_sc_hd__decap_3
X_6418_ _2103_ _2105_ _2302_ _2304_ VGND VGND VPWR VPWR _2305_ sky130_fd_sc_hd__o211ai_4
XTAP_TAPCELL_ROW_8_347 VGND VPWR sky130_fd_sc_hd__tapvpwrvgnd_1
XFILLER_0_214 VGND VGND VPWR VPWR sky130_fd_sc_hd__fill_1
X_6349_ _2227_ _2228_ VGND VGND VPWR VPWR _2229_ sky130_fd_sc_hd__xnor2_1
XFILLER_103_665 VGND VGND VPWR VPWR sky130_fd_sc_hd__decap_6
XFILLER_88_365 VPWR VGND VPWR VGND sky130_ef_sc_hd__decap_12
XFILLER_0_269 VGND VGND VPWR VPWR sky130_fd_sc_hd__fill_2
XFILLER_102_197 VPWR VGND VPWR VGND sky130_ef_sc_hd__decap_12
XFILLER_102_164 VPWR VGND VPWR VGND sky130_ef_sc_hd__decap_12
XFILLER_48_218 VGND VGND VPWR VPWR sky130_fd_sc_hd__decap_8
XFILLER_84_582 VGND VGND VPWR VPWR sky130_fd_sc_hd__decap_6
XFILLER_44_413 VGND VGND VPWR VPWR sky130_fd_sc_hd__fill_2
XTAP_TAPCELL_ROW_106_1528 VGND VPWR sky130_fd_sc_hd__tapvpwrvgnd_1
XFILLER_16_115 VGND VGND VPWR VPWR sky130_fd_sc_hd__decap_6
XFILLER_16_137 VGND VGND VPWR VPWR sky130_fd_sc_hd__decap_3
XFILLER_44_457 VPWR VGND VPWR VGND sky130_ef_sc_hd__decap_12
XFILLER_25_671 VGND VGND VPWR VPWR sky130_fd_sc_hd__fill_1
XFILLER_52_490 VGND VGND VPWR VPWR sky130_fd_sc_hd__decap_8
XFILLER_12_343 VGND VGND VPWR VPWR sky130_fd_sc_hd__decap_4
XFILLER_12_365 VPWR VGND VPWR VGND sky130_ef_sc_hd__decap_12
XFILLER_12_398 VPWR VGND VPWR VGND sky130_ef_sc_hd__decap_12
XFILLER_4_531 VGND VGND VPWR VPWR sky130_fd_sc_hd__fill_1
XFILLER_21_81 VPWR VGND VPWR VGND sky130_ef_sc_hd__decap_12
XFILLER_97_74 VPWR VGND VPWR VGND sky130_ef_sc_hd__decap_12
XFILLER_67_505 VGND VGND VPWR VPWR sky130_fd_sc_hd__decap_4
XFILLER_94_313 VGND VGND VPWR VPWR sky130_fd_sc_hd__decap_4
XFILLER_67_527 VGND VGND VPWR VPWR sky130_fd_sc_hd__decap_6
XFILLER_90_541 VGND VGND VPWR VPWR sky130_fd_sc_hd__decap_3
XFILLER_90_530 VGND VGND VPWR VPWR sky130_fd_sc_hd__fill_2
XFILLER_35_424 VPWR VGND VPWR VGND sky130_ef_sc_hd__decap_12
XFILLER_35_446 VGND VGND VPWR VPWR sky130_fd_sc_hd__fill_2
XFILLER_90_563 VGND VGND VPWR VPWR sky130_fd_sc_hd__decap_4
X_3981_ _3162_ _3169_ VGND VGND VPWR VPWR _3170_ sky130_fd_sc_hd__nand2_1
XFILLER_90_585 VGND VGND VPWR VPWR sky130_fd_sc_hd__decap_3
X_5720_ _1402_ _1410_ _1409_ VGND VGND VPWR VPWR _1543_ sky130_fd_sc_hd__a21o_1
XFILLER_94_3 VPWR VGND VPWR VGND sky130_ef_sc_hd__decap_12
XTAP_TAPCELL_ROW_61_978 VGND VPWR sky130_fd_sc_hd__tapvpwrvgnd_1
XFILLER_15_181 VGND VGND VPWR VPWR sky130_fd_sc_hd__decap_3
XFILLER_31_641 VPWR VGND VPWR VGND sky130_ef_sc_hd__decap_12
XTAP_TAPCELL_ROW_33_647 VGND VPWR sky130_fd_sc_hd__tapvpwrvgnd_1
XTAP_TAPCELL_ROW_61_989 VGND VPWR sky130_fd_sc_hd__tapvpwrvgnd_1
X_5651_ _1465_ _1466_ VGND VGND VPWR VPWR _1467_ sky130_fd_sc_hd__xnor2_1
XFILLER_31_685 VGND VGND VPWR VPWR sky130_fd_sc_hd__decap_6
X_4602_ _0362_ _0363_ _0355_ VGND VGND VPWR VPWR _0365_ sky130_fd_sc_hd__a21bo_1
X_5582_ _1385_ _1391_ VGND VGND VPWR VPWR _1392_ sky130_fd_sc_hd__nand2b_1
X_4533_ net252 net370 VGND VGND VPWR VPWR _0297_ sky130_fd_sc_hd__and2_1
XFILLER_7_391 VGND VGND VPWR VPWR sky130_fd_sc_hd__fill_1
XFILLER_7_83 VGND VGND VPWR VPWR sky130_fd_sc_hd__decap_8
XFILLER_116_278 VGND VGND VPWR VPWR sky130_fd_sc_hd__fill_2
X_4464_ _0227_ _0228_ _0180_ VGND VGND VPWR VPWR _0230_ sky130_fd_sc_hd__a21o_1
X_6203_ net465 net188 net343 net166 VGND VGND VPWR VPWR _2069_ sky130_fd_sc_hd__a22oi_1
X_4395_ net238 net225 net414 net406 VGND VGND VPWR VPWR _0162_ sky130_fd_sc_hd__nand4_1
X_3415_ net436 VGND VGND VPWR VPWR _0874_ sky130_fd_sc_hd__inv_2
XTAP_TAPCELL_ROW_5_317 VGND VPWR sky130_fd_sc_hd__tapvpwrvgnd_1
XTAP_TAPCELL_ROW_5_306 VGND VPWR sky130_fd_sc_hd__tapvpwrvgnd_1
X_6134_ _1989_ _1991_ _1792_ _1795_ VGND VGND VPWR VPWR _1994_ sky130_fd_sc_hd__o211a_1
XFILLER_100_613 VPWR VGND VPWR VGND sky130_ef_sc_hd__decap_12
XFILLER_97_184 VPWR VGND VPWR VGND sky130_ef_sc_hd__decap_12
XFILLER_85_335 VGND VGND VPWR VPWR sky130_fd_sc_hd__fill_1
X_6065_ _1907_ _1917_ VGND VGND VPWR VPWR _1918_ sky130_fd_sc_hd__xor2_1
XFILLER_100_657 VPWR VGND VPWR VGND sky130_ef_sc_hd__decap_12
X_5016_ _0772_ _0773_ _0731_ VGND VGND VPWR VPWR _0775_ sky130_fd_sc_hd__o21ai_1
XFILLER_26_15 VPWR VGND VPWR VGND sky130_ef_sc_hd__decap_12
XFILLER_26_446 VPWR VGND VPWR VGND sky130_ef_sc_hd__decap_12
XFILLER_53_265 VPWR VGND VPWR VGND sky130_ef_sc_hd__decap_12
X_5918_ net178 net172 net186 net341 VGND VGND VPWR VPWR _1759_ sky130_fd_sc_hd__and4_1
XFILLER_41_449 VPWR VGND VPWR VGND sky130_ef_sc_hd__decap_12
XFILLER_53_287 VGND VGND VPWR VPWR sky130_fd_sc_hd__fill_1
X_6898_ net182 _alu_i0.Datapath_i.fu_alu_33673_33851.out1\[24\] VGND VGND VPWR VPWR
+ _alu_i0.Datapath_i.reg_0.reg_out1\[24\] sky130_fd_sc_hd__dfxtp_1
XTAP_TAPCELL_ROW_101_1469 VGND VPWR sky130_fd_sc_hd__tapvpwrvgnd_1
XTAP_TAPCELL_ROW_101_1458 VGND VPWR sky130_fd_sc_hd__tapvpwrvgnd_1
X_5849_ _1677_ _1682_ _1683_ VGND VGND VPWR VPWR _1684_ sky130_fd_sc_hd__nand3_2
XFILLER_107_223 VGND VGND VPWR VPWR sky130_fd_sc_hd__fill_1
XFILLER_89_641 VPWR VGND VPWR VGND sky130_ef_sc_hd__decap_12
XFILLER_107_73 VGND VGND VPWR VPWR sky130_fd_sc_hd__fill_1
XFILLER_107_51 VGND VGND VPWR VPWR sky130_fd_sc_hd__decap_4
XFILLER_49_505 VPWR VGND VPWR VGND sky130_ef_sc_hd__decap_12
XTAP_TAPCELL_ROW_112_1598 VGND VPWR sky130_fd_sc_hd__tapvpwrvgnd_1
XFILLER_103_473 VGND VGND VPWR VPWR sky130_fd_sc_hd__decap_4
XFILLER_89_685 VGND VGND VPWR VPWR sky130_fd_sc_hd__decap_6
XFILLER_76_302 VGND VGND VPWR VPWR sky130_fd_sc_hd__decap_6
XFILLER_76_357 VGND VGND VPWR VPWR sky130_fd_sc_hd__decap_6
XFILLER_91_327 VGND VGND VPWR VPWR sky130_fd_sc_hd__fill_1
XFILLER_91_305 VGND VGND VPWR VPWR sky130_fd_sc_hd__decap_6
XFILLER_17_413 VPWR VGND VPWR VGND sky130_ef_sc_hd__decap_12
XFILLER_91_349 VPWR VGND VPWR VGND sky130_ef_sc_hd__decap_12
XFILLER_84_390 VGND VGND VPWR VPWR sky130_fd_sc_hd__decap_8
XFILLER_44_210 VPWR VGND VPWR VGND sky130_ef_sc_hd__decap_12
XFILLER_72_563 VPWR VGND VPWR VGND sky130_ef_sc_hd__decap_12
XTAP_TAPCELL_ROW_67_1055 VGND VPWR sky130_fd_sc_hd__tapvpwrvgnd_1
XFILLER_32_405 VPWR VGND VPWR VGND sky130_ef_sc_hd__decap_12
XFILLER_44_265 VGND VGND VPWR VPWR sky130_fd_sc_hd__decap_3
XTAP_TAPCELL_ROW_80_1211 VGND VPWR sky130_fd_sc_hd__tapvpwrvgnd_1
XFILLER_13_641 VPWR VGND VPWR VGND sky130_ef_sc_hd__decap_12
XFILLER_25_490 VPWR VGND VPWR VGND sky130_ef_sc_hd__decap_12
XFILLER_13_685 VGND VGND VPWR VPWR sky130_fd_sc_hd__decap_6
XTAP_TAPCELL_ROW_30_606 VGND VPWR sky130_fd_sc_hd__tapvpwrvgnd_1
XTAP_TAPCELL_ROW_30_617 VGND VPWR sky130_fd_sc_hd__tapvpwrvgnd_1
XFILLER_12_195 VGND VGND VPWR VPWR sky130_fd_sc_hd__fill_1
XFILLER_12_173 VGND VGND VPWR VPWR sky130_fd_sc_hd__fill_2
XTAP_TAPCELL_ROW_10_374 VGND VPWR sky130_fd_sc_hd__tapvpwrvgnd_1
XTAP_TAPCELL_ROW_78_1184 VGND VPWR sky130_fd_sc_hd__tapvpwrvgnd_1
XFILLER_113_237 VGND VGND VPWR VPWR sky130_fd_sc_hd__fill_1
XFILLER_99_449 VGND VGND VPWR VPWR sky130_fd_sc_hd__decap_6
XTAP_TAPCELL_ROW_91_1340 VGND VPWR sky130_fd_sc_hd__tapvpwrvgnd_1
XFILLER_113_248 VGND VGND VPWR VPWR sky130_fd_sc_hd__fill_1
X_4180_ _3353_ _3358_ _3359_ VGND VGND VPWR VPWR _3360_ sky130_fd_sc_hd__a21o_1
XFILLER_79_184 VGND VGND VPWR VPWR sky130_fd_sc_hd__decap_8
XFILLER_94_165 VPWR VGND VPWR VGND sky130_ef_sc_hd__decap_12
XTAP_TAPCELL_ROW_38_706 VGND VPWR sky130_fd_sc_hd__tapvpwrvgnd_1
XFILLER_48_560 VGND VGND VPWR VPWR sky130_fd_sc_hd__decap_4
XFILLER_94_187 VGND VGND VPWR VPWR sky130_fd_sc_hd__fill_1
X_6821_ _2732_ _2743_ VGND VGND VPWR VPWR _2744_ sky130_fd_sc_hd__xnor2_1
XTAP_TAPCELL_ROW_18_463 VGND VPWR sky130_fd_sc_hd__tapvpwrvgnd_1
X_3964_ _3153_ _3104_ net284 VGND VGND VPWR VPWR _3154_ sky130_fd_sc_hd__mux2_1
X_6752_ _2215_ _2616_ _2614_ VGND VGND VPWR VPWR _2668_ sky130_fd_sc_hd__o21ai_2
XFILLER_50_246 VGND VGND VPWR VPWR sky130_fd_sc_hd__decap_6
X_3895_ net244 _2673_ _2913_ net151 VGND VGND VPWR VPWR _3088_ sky130_fd_sc_hd__a211o_1
X_6683_ _2591_ _2592_ VGND VGND VPWR VPWR _2593_ sky130_fd_sc_hd__nor2_1
X_5703_ _1521_ _1522_ _1482_ VGND VGND VPWR VPWR _1524_ sky130_fd_sc_hd__a21oi_1
X_5634_ _1227_ _1229_ _1446_ _1448_ VGND VGND VPWR VPWR _1449_ sky130_fd_sc_hd__a211oi_1
X_5565_ _1371_ _1372_ _1352_ VGND VGND VPWR VPWR _1373_ sky130_fd_sc_hd__a21o_1
X_4516_ _0278_ _0279_ _0234_ VGND VGND VPWR VPWR _0281_ sky130_fd_sc_hd__o21ai_1
XFILLER_2_309 VGND VGND VPWR VPWR sky130_fd_sc_hd__fill_2
X_5496_ net375 net320 _1295_ _1296_ VGND VGND VPWR VPWR _1298_ sky130_fd_sc_hd__nand4_1
X_4447_ net355 net370 _0211_ _0212_ VGND VGND VPWR VPWR _0213_ sky130_fd_sc_hd__nand4_1
X_4378_ _0142_ _0143_ VGND VGND VPWR VPWR _0146_ sky130_fd_sc_hd__xnor2_1
XFILLER_85_110 VGND VGND VPWR VPWR sky130_fd_sc_hd__fill_2
X_6117_ net446 net212 _1972_ _1973_ VGND VGND VPWR VPWR _1976_ sky130_fd_sc_hd__a22o_1
XFILLER_112_281 VGND VGND VPWR VPWR sky130_fd_sc_hd__decap_4
XFILLER_100_421 VPWR VGND VPWR VGND sky130_ef_sc_hd__decap_12
XFILLER_85_121 VGND VGND VPWR VPWR sky130_fd_sc_hd__decap_8
X_6048_ _1896_ _1897_ _1875_ VGND VGND VPWR VPWR _1900_ sky130_fd_sc_hd__a21oi_1
XFILLER_85_198 VGND VGND VPWR VPWR sky130_fd_sc_hd__decap_8
XFILLER_26_210 VGND VGND VPWR VPWR sky130_fd_sc_hd__decap_3
XFILLER_54_552 VPWR VGND VPWR VGND sky130_ef_sc_hd__decap_12
XFILLER_14_405 VGND VGND VPWR VPWR sky130_fd_sc_hd__decap_8
XFILLER_81_382 VGND VGND VPWR VPWR sky130_fd_sc_hd__decap_8
XFILLER_41_279 VGND VGND VPWR VPWR sky130_fd_sc_hd__fill_1
XFILLER_5_103 VGND VGND VPWR VPWR sky130_fd_sc_hd__decap_8
XFILLER_6_637 VGND VGND VPWR VPWR sky130_fd_sc_hd__decap_6
XFILLER_5_125 VPWR VGND VPWR VGND sky130_ef_sc_hd__decap_12
XTAP_TAPCELL_ROW_114_1616 VGND VPWR sky130_fd_sc_hd__tapvpwrvgnd_1
XFILLER_108_587 VGND VGND VPWR VPWR sky130_fd_sc_hd__fill_1
XFILLER_96_419 VGND VGND VPWR VPWR sky130_fd_sc_hd__fill_1
XFILLER_78_43 VPWR VGND VPWR VGND sky130_ef_sc_hd__decap_12
XFILLER_1_375 VGND VGND VPWR VPWR sky130_fd_sc_hd__decap_3
XFILLER_103_281 VPWR VGND VPWR VGND sky130_ef_sc_hd__decap_12
XFILLER_94_53 VPWR VGND VPWR VGND sky130_ef_sc_hd__decap_12
XFILLER_92_625 VPWR VGND VPWR VGND sky130_ef_sc_hd__decap_12
XFILLER_76_165 VGND VGND VPWR VPWR sky130_fd_sc_hd__fill_1
XFILLER_91_113 VPWR VGND VPWR VGND sky130_ef_sc_hd__decap_12
XFILLER_17_210 VPWR VGND VPWR VGND sky130_ef_sc_hd__decap_12
XFILLER_92_669 VPWR VGND VPWR VGND sky130_ef_sc_hd__decap_12
XFILLER_17_265 VGND VGND VPWR VPWR sky130_fd_sc_hd__decap_3
XFILLER_60_533 VGND VGND VPWR VPWR sky130_fd_sc_hd__decap_4
XTAP_TAPCELL_ROW_15_433 VGND VPWR sky130_fd_sc_hd__tapvpwrvgnd_1
XTAP_TAPCELL_ROW_43_764 VGND VPWR sky130_fd_sc_hd__tapvpwrvgnd_1
XFILLER_9_420 VPWR VGND VPWR VGND sky130_ef_sc_hd__decap_12
X_3680_ net248 _2237_ VGND VGND VPWR VPWR _2882_ sky130_fd_sc_hd__or2_1
XFILLER_40_290 VGND VGND VPWR VPWR sky130_fd_sc_hd__decap_3
X_5350_ _1117_ _1136_ _1137_ VGND VGND VPWR VPWR _1139_ sky130_fd_sc_hd__nand3_1
XFILLER_57_3 VPWR VGND VPWR VGND sky130_ef_sc_hd__decap_12
XFILLER_114_513 VPWR VGND VPWR VGND sky130_ef_sc_hd__decap_12
X_4301_ net148 _0068_ _0070_ _0071_ VGND VGND VPWR VPWR net102 sky130_fd_sc_hd__a31o_1
X_5281_ _1062_ _1063_ VGND VGND VPWR VPWR _1064_ sky130_fd_sc_hd__nand2_1
XFILLER_114_557 VPWR VGND VPWR VGND sky130_ef_sc_hd__decap_12
X_4232_ net56 net24 VGND VGND VPWR VPWR _0008_ sky130_fd_sc_hd__nand2b_1
XFILLER_99_279 VGND VGND VPWR VPWR sky130_fd_sc_hd__fill_1
XFILLER_68_633 VGND VGND VPWR VPWR sky130_fd_sc_hd__decap_8
X_4163_ net435 net436 net439 net440 net346 net277 VGND VGND VPWR VPWR _3344_ sky130_fd_sc_hd__mux4_1
XFILLER_67_143 VGND VGND VPWR VPWR sky130_fd_sc_hd__decap_8
X_4094_ _3277_ _3239_ net278 VGND VGND VPWR VPWR _3278_ sky130_fd_sc_hd__mux2_1
XFILLER_28_508 VGND VGND VPWR VPWR sky130_fd_sc_hd__decap_3
XFILLER_91_691 VGND VGND VPWR VPWR sky130_fd_sc_hd__fill_1
X_4996_ net387 net215 _0751_ _0752_ VGND VGND VPWR VPWR _0754_ sky130_fd_sc_hd__nand4_2
XFILLER_63_393 VGND VGND VPWR VPWR sky130_fd_sc_hd__fill_1
X_6804_ _2720_ _2721_ _2718_ _2719_ VGND VGND VPWR VPWR _2725_ sky130_fd_sc_hd__a211o_1
X_3947_ net154 _3137_ VGND VGND VPWR VPWR _3138_ sky130_fd_sc_hd__nand2_1
X_6735_ _2647_ _2648_ VGND VGND VPWR VPWR _2650_ sky130_fd_sc_hd__xnor2_1
XFILLER_23_27 VPWR VGND VPWR VGND sky130_ef_sc_hd__decap_12
XFILLER_109_329 VGND VGND VPWR VPWR sky130_fd_sc_hd__decap_6
X_3878_ _3062_ _3069_ _3070_ _3071_ VGND VGND VPWR VPWR _alu_i0.Datapath_i.fu_alu_33673_33851.out1\[13\]
+ sky130_fd_sc_hd__or4_1
X_6666_ _2359_ _2362_ _2360_ VGND VGND VPWR VPWR _2574_ sky130_fd_sc_hd__o21ba_1
X_6597_ net405 net254 VGND VGND VPWR VPWR _2499_ sky130_fd_sc_hd__nand2_1
X_5617_ _1427_ _1428_ _1271_ VGND VGND VPWR VPWR _1431_ sky130_fd_sc_hd__a21oi_1
X_5548_ _1236_ _1238_ VGND VGND VPWR VPWR _1355_ sky130_fd_sc_hd__nand2_1
XFILLER_105_524 VPWR VGND VPWR VGND sky130_ef_sc_hd__decap_12
XFILLER_3_629 VPWR VGND VPWR VGND sky130_ef_sc_hd__decap_12
X_5479_ net429 net337 VGND VGND VPWR VPWR _1280_ sky130_fd_sc_hd__nand2_1
Xfanout410 net27 VGND VGND VPWR VPWR net410 sky130_fd_sc_hd__clkbuf_4
Xfanout432 net434 VGND VGND VPWR VPWR net432 sky130_fd_sc_hd__buf_2
Xfanout421 net23 VGND VGND VPWR VPWR net421 sky130_fd_sc_hd__buf_4
Xfanout454 net455 VGND VGND VPWR VPWR net454 sky130_fd_sc_hd__buf_2
Xfanout465 net467 VGND VGND VPWR VPWR net465 sky130_fd_sc_hd__clkbuf_4
Xfanout443 net444 VGND VGND VPWR VPWR net443 sky130_fd_sc_hd__clkbuf_4
XFILLER_48_35 VGND VGND VPWR VPWR sky130_fd_sc_hd__decap_3
XFILLER_100_262 VGND VGND VPWR VPWR sky130_fd_sc_hd__fill_1
XFILLER_86_452 VPWR VGND VPWR VGND sky130_ef_sc_hd__decap_12
XFILLER_58_165 VGND VGND VPWR VPWR sky130_fd_sc_hd__decap_4
XFILLER_48_79 VGND VGND VPWR VPWR sky130_fd_sc_hd__decap_4
XFILLER_104_41 VPWR VGND VPWR VGND sky130_ef_sc_hd__decap_12
XFILLER_100_295 VGND VGND VPWR VPWR sky130_fd_sc_hd__fill_2
XPHY_EDGE_ROW_100_Left_217 VGND VGND VPWR VPWR sky130_fd_sc_hd__decap_3
XFILLER_73_113 VGND VGND VPWR VPWR sky130_fd_sc_hd__fill_1
XFILLER_46_338 VPWR VGND VPWR VGND sky130_ef_sc_hd__decap_12
XFILLER_104_85 VPWR VGND VPWR VGND sky130_ef_sc_hd__decap_12
XFILLER_74_669 VPWR VGND VPWR VGND sky130_ef_sc_hd__decap_12
XFILLER_73_157 VGND VGND VPWR VPWR sky130_fd_sc_hd__decap_8
XFILLER_73_146 VGND VGND VPWR VPWR sky130_fd_sc_hd__decap_6
XTAP_TAPCELL_ROW_64_1014 VGND VPWR sky130_fd_sc_hd__tapvpwrvgnd_1
XFILLER_27_596 VPWR VGND VPWR VGND sky130_ef_sc_hd__decap_12
XFILLER_81_190 VGND VGND VPWR VPWR sky130_fd_sc_hd__decap_8
XTAP_TAPCELL_ROW_64_1025 VGND VPWR sky130_fd_sc_hd__tapvpwrvgnd_1
XFILLER_14_268 VGND VGND VPWR VPWR sky130_fd_sc_hd__fill_1
XTAP_TAPCELL_ROW_40_734 VGND VPWR sky130_fd_sc_hd__tapvpwrvgnd_1
XFILLER_10_463 VPWR VGND VPWR VGND sky130_ef_sc_hd__decap_12
XTAP_TAPCELL_ROW_20_491 VGND VPWR sky130_fd_sc_hd__tapvpwrvgnd_1
XTAP_TAPCELL_ROW_75_1154 VGND VPWR sky130_fd_sc_hd__tapvpwrvgnd_1
XFILLER_111_505 VPWR VGND VPWR VGND sky130_ef_sc_hd__decap_12
XFILLER_96_205 VGND VGND VPWR VPWR sky130_fd_sc_hd__decap_3
XFILLER_96_249 VGND VGND VPWR VPWR sky130_fd_sc_hd__decap_3
XFILLER_77_430 VPWR VGND VPWR VGND sky130_ef_sc_hd__decap_12
XFILLER_37_305 VPWR VGND VPWR VGND sky130_ef_sc_hd__decap_12
XFILLER_77_485 VGND VGND VPWR VPWR sky130_fd_sc_hd__decap_6
XFILLER_37_349 VPWR VGND VPWR VGND sky130_ef_sc_hd__decap_12
XTAP_TAPCELL_ROW_48_823 VGND VPWR sky130_fd_sc_hd__tapvpwrvgnd_1
XFILLER_92_477 VPWR VGND VPWR VGND sky130_ef_sc_hd__decap_12
XFILLER_18_530 VGND VGND VPWR VPWR sky130_fd_sc_hd__fill_2
XFILLER_18_541 VGND VGND VPWR VPWR sky130_fd_sc_hd__decap_8
XFILLER_92_499 VPWR VGND VPWR VGND sky130_ef_sc_hd__decap_12
X_4850_ _0607_ _0608_ _0529_ _0532_ VGND VGND VPWR VPWR _0610_ sky130_fd_sc_hd__o211ai_2
XTAP_TAPCELL_ROW_86_1283 VGND VPWR sky130_fd_sc_hd__tapvpwrvgnd_1
XFILLER_73_691 VGND VGND VPWR VPWR sky130_fd_sc_hd__fill_1
XTAP_TAPCELL_ROW_28_591 VGND VPWR sky130_fd_sc_hd__tapvpwrvgnd_1
XFILLER_45_393 VPWR VGND VPWR VGND sky130_ef_sc_hd__decap_12
X_3801_ _2695_ _2997_ net151 VGND VGND VPWR VPWR _2998_ sky130_fd_sc_hd__mux2_1
X_4781_ _0540_ _0541_ VGND VGND VPWR VPWR _0542_ sky130_fd_sc_hd__xnor2_1
X_6520_ _2242_ _2250_ _2247_ VGND VGND VPWR VPWR _2416_ sky130_fd_sc_hd__a21oi_1
X_3732_ _2820_ _2823_ net248 VGND VGND VPWR VPWR _2932_ sky130_fd_sc_hd__mux2_1
XFILLER_9_250 VPWR VGND VPWR VGND sky130_ef_sc_hd__decap_12
X_3663_ net162 _1768_ _2865_ VGND VGND VPWR VPWR _2866_ sky130_fd_sc_hd__a21o_1
X_6451_ _2338_ _2339_ VGND VGND VPWR VPWR _2340_ sky130_fd_sc_hd__xnor2_1
X_5402_ _1142_ _1143_ _1193_ _1194_ VGND VGND VPWR VPWR _1196_ sky130_fd_sc_hd__o22a_1
X_6382_ net234 net222 net438 net436 VGND VGND VPWR VPWR _2265_ sky130_fd_sc_hd__and4_1
X_3594_ _1168_ _1898_ _2798_ VGND VGND VPWR VPWR _2799_ sky130_fd_sc_hd__o21a_1
X_5333_ net3 net197 _1045_ _2981_ _2963_ VGND VGND VPWR VPWR _1120_ sky130_fd_sc_hd__a32o_1
XFILLER_114_365 VGND VGND VPWR VPWR sky130_fd_sc_hd__decap_8
X_5264_ net433 net187 net342 net365 VGND VGND VPWR VPWR _1045_ sky130_fd_sc_hd__a22o_1
X_5195_ _0969_ _0940_ VGND VGND VPWR VPWR _0970_ sky130_fd_sc_hd__and2b_1
X_4215_ _3390_ _3392_ VGND VGND VPWR VPWR _3393_ sky130_fd_sc_hd__or2_1
X_4146_ net233 _3327_ VGND VGND VPWR VPWR _3328_ sky130_fd_sc_hd__or2_1
XFILLER_68_485 VGND VGND VPWR VPWR sky130_fd_sc_hd__fill_2
XFILLER_55_113 VGND VGND VPWR VPWR sky130_fd_sc_hd__decap_4
XFILLER_18_27 VGND VGND VPWR VPWR sky130_fd_sc_hd__fill_1
XFILLER_83_455 VGND VGND VPWR VPWR sky130_fd_sc_hd__fill_1
XFILLER_83_444 VGND VGND VPWR VPWR sky130_fd_sc_hd__decap_4
X_4077_ net157 _3261_ VGND VGND VPWR VPWR _3262_ sky130_fd_sc_hd__and2_1
XFILLER_56_669 VPWR VGND VPWR VGND sky130_ef_sc_hd__decap_12
XFILLER_83_477 VPWR VGND VPWR VGND sky130_ef_sc_hd__decap_12
XFILLER_70_127 VGND VGND VPWR VPWR sky130_fd_sc_hd__decap_6
XFILLER_34_15 VPWR VGND VPWR VGND sky130_ef_sc_hd__decap_12
X_4979_ net251 net220 _0735_ _0736_ VGND VGND VPWR VPWR _0737_ sky130_fd_sc_hd__a22o_1
XFILLER_51_396 VPWR VGND VPWR VGND sky130_ef_sc_hd__decap_12
X_6718_ _2397_ _2399_ _2629_ VGND VGND VPWR VPWR _2632_ sky130_fd_sc_hd__or3_1
X_6649_ _2415_ _2416_ _2418_ VGND VGND VPWR VPWR _2556_ sky130_fd_sc_hd__o21a_1
XFILLER_3_415 VGND VGND VPWR VPWR sky130_fd_sc_hd__fill_1
XFILLER_105_332 VGND VGND VPWR VPWR sky130_fd_sc_hd__decap_4
Xfanout240 net241 VGND VGND VPWR VPWR net240 sky130_fd_sc_hd__buf_2
XFILLER_115_51 VGND VGND VPWR VPWR sky130_fd_sc_hd__decap_4
Xfanout251 net252 VGND VGND VPWR VPWR net251 sky130_fd_sc_hd__buf_2
XFILLER_59_441 VGND VGND VPWR VPWR sky130_fd_sc_hd__decap_6
Xfanout262 net5 VGND VGND VPWR VPWR net262 sky130_fd_sc_hd__clkbuf_4
Xfanout273 net46 VGND VGND VPWR VPWR net273 sky130_fd_sc_hd__buf_2
XFILLER_86_260 VGND VGND VPWR VPWR sky130_fd_sc_hd__decap_8
Xfanout284 net288 VGND VGND VPWR VPWR net284 sky130_fd_sc_hd__clkbuf_4
XFILLER_74_411 VGND VGND VPWR VPWR sky130_fd_sc_hd__decap_4
XTAP_TAPCELL_ROW_70_1095 VGND VPWR sky130_fd_sc_hd__tapvpwrvgnd_1
Xfanout295 net43 VGND VGND VPWR VPWR net295 sky130_fd_sc_hd__buf_2
XFILLER_46_102 VPWR VGND VPWR VGND sky130_ef_sc_hd__decap_12
XTAP_TAPCELL_ROW_109_1559 VGND VPWR sky130_fd_sc_hd__tapvpwrvgnd_1
XFILLER_91_21 VPWR VGND VPWR VGND sky130_ef_sc_hd__decap_12
XFILLER_27_393 VPWR VGND VPWR VGND sky130_ef_sc_hd__decap_12
XTAP_TAPCELL_ROW_25_550 VGND VPWR sky130_fd_sc_hd__tapvpwrvgnd_1
XTAP_TAPCELL_ROW_53_892 VGND VPWR sky130_fd_sc_hd__tapvpwrvgnd_1
XFILLER_30_514 VGND VGND VPWR VPWR sky130_fd_sc_hd__fill_2
XFILLER_42_385 VPWR VGND VPWR VGND sky130_ef_sc_hd__decap_12
XFILLER_6_253 VGND VGND VPWR VPWR sky130_fd_sc_hd__decap_4
XFILLER_6_231 VPWR VGND VPWR VGND sky130_ef_sc_hd__decap_12
XFILLER_6_220 VGND VGND VPWR VPWR sky130_fd_sc_hd__decap_6
XFILLER_109_671 VGND VGND VPWR VPWR sky130_fd_sc_hd__fill_1
XFILLER_6_297 VGND VGND VPWR VPWR sky130_fd_sc_hd__decap_8
XFILLER_111_335 VGND VGND VPWR VPWR sky130_fd_sc_hd__fill_1
XFILLER_2_470 VGND VGND VPWR VPWR sky130_fd_sc_hd__fill_1
X_4000_ _1887_ _3186_ _3181_ net123 VGND VGND VPWR VPWR _3188_ sky130_fd_sc_hd__a2bb2o_1
XTAP_TAPCELL_ROW_88_1312 VGND VPWR sky130_fd_sc_hd__tapvpwrvgnd_1
XFILLER_37_113 VPWR VGND VPWR VGND sky130_ef_sc_hd__decap_12
XFILLER_37_135 VPWR VGND VPWR VGND sky130_ef_sc_hd__decap_12
XFILLER_38_669 VPWR VGND VPWR VGND sky130_ef_sc_hd__decap_12
XFILLER_65_477 VGND VGND VPWR VPWR sky130_fd_sc_hd__fill_1
XFILLER_53_617 VPWR VGND VPWR VGND sky130_ef_sc_hd__decap_12
XFILLER_1_85 VGND VGND VPWR VPWR sky130_fd_sc_hd__fill_1
X_5951_ _1644_ _1646_ _1791_ _1793_ VGND VGND VPWR VPWR _1795_ sky130_fd_sc_hd__a211o_1
XFILLER_37_179 VGND VGND VPWR VPWR sky130_fd_sc_hd__decap_6
X_4902_ _0548_ _0556_ _0555_ VGND VGND VPWR VPWR _0661_ sky130_fd_sc_hd__a21o_1
X_5882_ _1453_ _1581_ VGND VGND VPWR VPWR _1720_ sky130_fd_sc_hd__and2b_1
XFILLER_21_503 VGND VGND VPWR VPWR sky130_fd_sc_hd__fill_1
XFILLER_33_341 VGND VGND VPWR VPWR sky130_fd_sc_hd__decap_6
X_4833_ _0578_ _0590_ _0591_ VGND VGND VPWR VPWR _0593_ sky130_fd_sc_hd__nand3_1
XFILLER_60_171 VGND VGND VPWR VPWR sky130_fd_sc_hd__fill_1
X_4764_ _0450_ _0453_ _0523_ _0524_ VGND VGND VPWR VPWR _0525_ sky130_fd_sc_hd__o211a_1
XTAP_TAPCELL_ROW_99_1441 VGND VPWR sky130_fd_sc_hd__tapvpwrvgnd_1
X_3715_ _1266_ _2911_ _2915_ net119 VGND VGND VPWR VPWR _2916_ sky130_fd_sc_hd__a22o_1
X_6503_ _2396_ _2395_ VGND VGND VPWR VPWR _2397_ sky130_fd_sc_hd__and2b_1
X_4695_ _0418_ _0455_ _0456_ VGND VGND VPWR VPWR _0457_ sky130_fd_sc_hd__or3_1
X_6434_ _2320_ _2321_ VGND VGND VPWR VPWR _2322_ sky130_fd_sc_hd__nand2_1
X_3646_ _2845_ _2847_ VGND VGND VPWR VPWR _2849_ sky130_fd_sc_hd__and2_1
XFILLER_115_641 VPWR VGND VPWR VGND sky130_ef_sc_hd__decap_12
X_3577_ net163 net423 _1779_ VGND VGND VPWR VPWR _2641_ sky130_fd_sc_hd__a21bo_1
X_6365_ _3072_ _2245_ VGND VGND VPWR VPWR _2246_ sky130_fd_sc_hd__xnor2_1
XFILLER_115_685 VGND VGND VPWR VPWR sky130_fd_sc_hd__decap_6
XFILLER_88_525 VGND VGND VPWR VPWR sky130_fd_sc_hd__fill_1
X_5316_ _0999_ _1007_ _1006_ VGND VGND VPWR VPWR _1101_ sky130_fd_sc_hd__o21ba_1
X_6296_ _2010_ _2015_ VGND VGND VPWR VPWR _2171_ sky130_fd_sc_hd__nor2_1
XFILLER_114_195 VGND VGND VPWR VPWR sky130_fd_sc_hd__fill_1
XFILLER_88_547 VGND VGND VPWR VPWR sky130_fd_sc_hd__fill_1
X_5247_ _1023_ _1024_ _1013_ VGND VGND VPWR VPWR _1027_ sky130_fd_sc_hd__a21oi_2
XFILLER_29_15 VPWR VGND VPWR VGND sky130_ef_sc_hd__decap_12
X_5178_ _0800_ _0802_ _0801_ VGND VGND VPWR VPWR _0952_ sky130_fd_sc_hd__a21bo_1
XFILLER_29_614 VGND VGND VPWR VPWR sky130_fd_sc_hd__fill_2
X_4129_ net154 _1517_ net118 _3311_ VGND VGND VPWR VPWR _alu_i0.Datapath_i.fu_alu_33673_33851.out1\[24\]
+ sky130_fd_sc_hd__a31o_1
XFILLER_71_403 VGND VGND VPWR VPWR sky130_fd_sc_hd__decap_6
XTAP_TAPCELL_ROW_3_289 VGND VPWR sky130_fd_sc_hd__tapvpwrvgnd_1
XFILLER_83_296 VPWR VGND VPWR VGND sky130_ef_sc_hd__decap_12
XFILLER_71_458 VPWR VGND VPWR VGND sky130_ef_sc_hd__decap_12
XFILLER_71_447 VGND VGND VPWR VPWR sky130_fd_sc_hd__fill_1
XFILLER_24_330 VGND VGND VPWR VPWR sky130_fd_sc_hd__fill_1
XFILLER_37_691 VGND VGND VPWR VPWR sky130_fd_sc_hd__fill_1
XFILLER_24_363 VGND VGND VPWR VPWR sky130_fd_sc_hd__fill_1
XFILLER_51_182 VGND VGND VPWR VPWR sky130_fd_sc_hd__decap_4
XFILLER_61_57 VGND VGND VPWR VPWR sky130_fd_sc_hd__fill_2
XFILLER_12_547 VGND VGND VPWR VPWR sky130_fd_sc_hd__fill_2
XFILLER_8_507 VPWR VGND VPWR VGND sky130_ef_sc_hd__decap_12
XTAP_TAPCELL_ROW_22_520 VGND VPWR sky130_fd_sc_hd__tapvpwrvgnd_1
XTAP_TAPCELL_ROW_50_851 VGND VPWR sky130_fd_sc_hd__tapvpwrvgnd_1
XFILLER_3_223 VGND VGND VPWR VPWR sky130_fd_sc_hd__fill_1
XTAP_TAPCELL_ROW_72_1113 VGND VPWR sky130_fd_sc_hd__tapvpwrvgnd_1
XFILLER_79_547 VGND VGND VPWR VPWR sky130_fd_sc_hd__fill_1
XFILLER_79_569 VGND VGND VPWR VPWR sky130_fd_sc_hd__fill_2
XFILLER_86_76 VGND VGND VPWR VPWR sky130_fd_sc_hd__decap_8
XFILLER_66_219 VGND VGND VPWR VPWR sky130_fd_sc_hd__fill_1
XFILLER_19_113 VGND VGND VPWR VPWR sky130_fd_sc_hd__decap_8
XFILLER_74_241 VGND VGND VPWR VPWR sky130_fd_sc_hd__decap_3
XTAP_TAPCELL_ROW_58_951 VGND VPWR sky130_fd_sc_hd__tapvpwrvgnd_1
XFILLER_19_81 VGND VGND VPWR VPWR sky130_fd_sc_hd__fill_1
XFILLER_35_606 VGND VGND VPWR VPWR sky130_fd_sc_hd__decap_8
XFILLER_35_617 VPWR VGND VPWR VGND sky130_ef_sc_hd__decap_12
XTAP_TAPCELL_ROW_83_1253 VGND VPWR sky130_fd_sc_hd__tapvpwrvgnd_1
XTAP_TAPCELL_ROW_83_1242 VGND VPWR sky130_fd_sc_hd__tapvpwrvgnd_1
XFILLER_15_374 VGND VGND VPWR VPWR sky130_fd_sc_hd__fill_1
XFILLER_42_160 VGND VGND VPWR VPWR sky130_fd_sc_hd__decap_6
XFILLER_30_377 VPWR VGND VPWR VGND sky130_ef_sc_hd__decap_12
X_3500_ _1768_ _1790_ net162 VGND VGND VPWR VPWR _1801_ sky130_fd_sc_hd__mux2_1
X_4480_ _0242_ _0243_ _0244_ VGND VGND VPWR VPWR _0245_ sky130_fd_sc_hd__and3_1
XFILLER_7_573 VPWR VGND VPWR VGND sky130_ef_sc_hd__decap_12
XFILLER_116_449 VPWR VGND VPWR VGND sky130_ef_sc_hd__decap_12
XFILLER_109_490 VPWR VGND VPWR VGND sky130_ef_sc_hd__decap_12
X_3431_ net68 _1026_ VGND VGND VPWR VPWR _1048_ sky130_fd_sc_hd__nand2_2
XTAP_TAPCELL_ROW_94_1382 VGND VPWR sky130_fd_sc_hd__tapvpwrvgnd_1
X_6150_ _2010_ _2011_ VGND VGND VPWR VPWR _2012_ sky130_fd_sc_hd__or2_1
XFILLER_97_333 VGND VGND VPWR VPWR sky130_fd_sc_hd__decap_3
X_5101_ _0847_ _0865_ _0866_ VGND VGND VPWR VPWR _0868_ sky130_fd_sc_hd__nand3_2
XFILLER_85_517 VGND VGND VPWR VPWR sky130_fd_sc_hd__decap_6
X_6081_ _1918_ _1933_ _1935_ VGND VGND VPWR VPWR _1936_ sky130_fd_sc_hd__or3_2
X_5032_ _alu_i0.Datapath_i.reg_0.reg_out1\[16\] _0792_ net146 VGND VGND VPWR VPWR
+ net84 sky130_fd_sc_hd__mux2_1
XFILLER_93_561 VGND VGND VPWR VPWR sky130_fd_sc_hd__decap_3
XFILLER_53_447 VGND VGND VPWR VPWR sky130_fd_sc_hd__fill_1
XFILLER_53_425 VGND VGND VPWR VPWR sky130_fd_sc_hd__decap_3
XTAP_TAPCELL_ROW_0_237 VGND VPWR sky130_fd_sc_hd__tapvpwrvgnd_1
XTAP_TAPCELL_ROW_0_248 VGND VPWR sky130_fd_sc_hd__tapvpwrvgnd_1
XFILLER_19_691 VGND VGND VPWR VPWR sky130_fd_sc_hd__fill_1
XFILLER_25_127 VPWR VGND VPWR VGND sky130_ef_sc_hd__decap_12
X_5934_ net429 net314 net305 net360 VGND VGND VPWR VPWR _1776_ sky130_fd_sc_hd__a22o_1
XFILLER_15_39 VPWR VGND VPWR VGND sky130_ef_sc_hd__decap_12
XTAP_TAPCELL_ROW_36_678 VGND VPWR sky130_fd_sc_hd__tapvpwrvgnd_1
XFILLER_61_480 VGND VGND VPWR VPWR sky130_fd_sc_hd__decap_3
XTAP_TAPCELL_ROW_36_689 VGND VPWR sky130_fd_sc_hd__tapvpwrvgnd_1
X_5865_ _1559_ _1563_ _1699_ _1700_ VGND VGND VPWR VPWR _1701_ sky130_fd_sc_hd__a211oi_2
X_4816_ _2314_ _0575_ VGND VGND VPWR VPWR _0576_ sky130_fd_sc_hd__or2_1
XFILLER_21_377 VPWR VGND VPWR VGND sky130_ef_sc_hd__decap_12
X_5796_ _1622_ _1623_ _1624_ VGND VGND VPWR VPWR _1625_ sky130_fd_sc_hd__and3_1
X_4747_ net393 net379 net210 net202 VGND VGND VPWR VPWR _0508_ sky130_fd_sc_hd__nand4_1
XFILLER_31_27 VPWR VGND VPWR VGND sky130_ef_sc_hd__decap_12
X_4678_ net379 net215 _0438_ _0439_ VGND VGND VPWR VPWR _0440_ sky130_fd_sc_hd__a22o_1
XFILLER_107_405 VPWR VGND VPWR VGND sky130_ef_sc_hd__decap_12
XFILLER_107_449 VPWR VGND VPWR VGND sky130_ef_sc_hd__decap_12
X_3629_ net416 net408 net400 net392 net354 net285 VGND VGND VPWR VPWR _2833_ sky130_fd_sc_hd__mux4_1
X_6417_ _2300_ _2301_ _2282_ VGND VGND VPWR VPWR _2304_ sky130_fd_sc_hd__a21o_1
X_6348_ net448 net193 VGND VGND VPWR VPWR _2228_ sky130_fd_sc_hd__nand2_1
XTAP_TAPCELL_ROW_8_348 VGND VPWR sky130_fd_sc_hd__tapvpwrvgnd_1
XFILLER_88_377 VGND VGND VPWR VPWR sky130_fd_sc_hd__fill_2
X_6279_ _1939_ _1941_ _2149_ _2151_ VGND VGND VPWR VPWR _2153_ sky130_fd_sc_hd__a211o_1
XFILLER_102_176 VGND VGND VPWR VPWR sky130_fd_sc_hd__decap_4
XFILLER_29_455 VGND VGND VPWR VPWR sky130_fd_sc_hd__decap_6
XTAP_TAPCELL_ROW_106_1518 VGND VPWR sky130_fd_sc_hd__tapvpwrvgnd_1
XFILLER_56_241 VGND VGND VPWR VPWR sky130_fd_sc_hd__decap_6
XFILLER_56_57 VGND VGND VPWR VPWR sky130_fd_sc_hd__fill_1
XTAP_TAPCELL_ROW_55_910 VGND VPWR sky130_fd_sc_hd__tapvpwrvgnd_1
XFILLER_17_606 VGND VGND VPWR VPWR sky130_fd_sc_hd__decap_8
XFILLER_17_617 VPWR VGND VPWR VGND sky130_ef_sc_hd__decap_12
XFILLER_112_41 VPWR VGND VPWR VGND sky130_ef_sc_hd__decap_12
XTAP_TAPCELL_ROW_106_1529 VGND VPWR sky130_fd_sc_hd__tapvpwrvgnd_1
XFILLER_112_85 VPWR VGND VPWR VGND sky130_ef_sc_hd__decap_12
XFILLER_44_469 VGND VGND VPWR VPWR sky130_fd_sc_hd__decap_6
XFILLER_40_631 VPWR VGND VPWR VGND sky130_ef_sc_hd__decap_12
XFILLER_12_377 VPWR VGND VPWR VGND sky130_ef_sc_hd__decap_12
XFILLER_99_609 VGND VGND VPWR VPWR sky130_fd_sc_hd__decap_6
XFILLER_98_108 VGND VGND VPWR VPWR sky130_fd_sc_hd__decap_8
XFILLER_21_93 VPWR VGND VPWR VGND sky130_ef_sc_hd__decap_12
XFILLER_4_587 VGND VGND VPWR VPWR sky130_fd_sc_hd__fill_1
XFILLER_97_86 VPWR VGND VPWR VGND sky130_ef_sc_hd__decap_12
XFILLER_75_561 VPWR VGND VPWR VGND sky130_ef_sc_hd__decap_12
XFILLER_75_594 VPWR VGND VPWR VGND sky130_ef_sc_hd__decap_12
X_3980_ _3129_ _3143_ _3168_ VGND VGND VPWR VPWR _3169_ sky130_fd_sc_hd__o21a_1
XFILLER_15_160 VGND VGND VPWR VPWR sky130_fd_sc_hd__decap_3
XTAP_TAPCELL_ROW_61_979 VGND VPWR sky130_fd_sc_hd__tapvpwrvgnd_1
X_5650_ net411 net275 VGND VGND VPWR VPWR _1466_ sky130_fd_sc_hd__nand2_1
XFILLER_31_653 VPWR VGND VPWR VGND sky130_ef_sc_hd__decap_12
XTAP_TAPCELL_ROW_33_648 VGND VPWR sky130_fd_sc_hd__tapvpwrvgnd_1
X_4601_ _0355_ _0362_ _0363_ VGND VGND VPWR VPWR _0364_ sky130_fd_sc_hd__nand3b_1
XFILLER_87_3 VPWR VGND VPWR VGND sky130_ef_sc_hd__decap_12
XFILLER_30_141 VPWR VGND VPWR VGND sky130_ef_sc_hd__decap_12
XTAP_TAPCELL_ROW_96_1400 VGND VPWR sky130_fd_sc_hd__tapvpwrvgnd_1
X_5581_ _1389_ _1390_ VGND VGND VPWR VPWR _1391_ sky130_fd_sc_hd__xnor2_1
XFILLER_30_185 VGND VGND VPWR VPWR sky130_fd_sc_hd__decap_8
X_4532_ net287 net370 _0247_ _0245_ VGND VGND VPWR VPWR _0296_ sky130_fd_sc_hd__a31o_1
XFILLER_7_51 VGND VGND VPWR VPWR sky130_fd_sc_hd__decap_4
X_4463_ _0180_ _0227_ _0228_ VGND VGND VPWR VPWR _0229_ sky130_fd_sc_hd__and3_1
XFILLER_104_419 VGND VGND VPWR VPWR sky130_fd_sc_hd__fill_1
X_6202_ net166 net464 net185 net340 VGND VGND VPWR VPWR _2068_ sky130_fd_sc_hd__and4_1
X_3414_ net443 VGND VGND VPWR VPWR _0863_ sky130_fd_sc_hd__inv_2
X_4394_ net286 net391 VGND VGND VPWR VPWR _0161_ sky130_fd_sc_hd__nand2_1
XPHY_EDGE_ROW_15_Right_15 VGND VGND VPWR VPWR sky130_fd_sc_hd__decap_3
XTAP_TAPCELL_ROW_5_307 VGND VPWR sky130_fd_sc_hd__tapvpwrvgnd_1
X_6133_ _1992_ VGND VGND VPWR VPWR _1993_ sky130_fd_sc_hd__inv_2
XFILLER_100_625 VPWR VGND VPWR VGND sky130_ef_sc_hd__decap_12
X_6064_ _1915_ _1916_ VGND VGND VPWR VPWR _1917_ sky130_fd_sc_hd__nand2b_1
XFILLER_100_669 VPWR VGND VPWR VGND sky130_ef_sc_hd__decap_12
XFILLER_97_196 VPWR VGND VPWR VGND sky130_ef_sc_hd__decap_12
X_5015_ _0731_ _0772_ _0773_ VGND VGND VPWR VPWR _0774_ sky130_fd_sc_hd__or3_2
XFILLER_85_358 VGND VGND VPWR VPWR sky130_fd_sc_hd__decap_3
XFILLER_85_347 VGND VGND VPWR VPWR sky130_fd_sc_hd__fill_2
XFILLER_93_391 VGND VGND VPWR VPWR sky130_fd_sc_hd__fill_1
XFILLER_81_531 VPWR VGND VPWR VGND sky130_ef_sc_hd__decap_12
XFILLER_26_27 VGND VGND VPWR VPWR sky130_fd_sc_hd__fill_1
XPHY_EDGE_ROW_24_Right_24 VGND VGND VPWR VPWR sky130_fd_sc_hd__decap_3
XFILLER_26_458 VGND VGND VPWR VPWR sky130_fd_sc_hd__fill_2
XFILLER_81_586 VPWR VGND VPWR VGND sky130_ef_sc_hd__decap_12
X_5917_ _1754_ _1755_ _1610_ VGND VGND VPWR VPWR _1758_ sky130_fd_sc_hd__a21oi_1
XFILLER_53_277 VGND VGND VPWR VPWR sky130_fd_sc_hd__decap_3
X_6897_ net182 _alu_i0.Datapath_i.fu_alu_33673_33851.out1\[23\] VGND VGND VPWR VPWR
+ _alu_i0.Datapath_i.reg_0.reg_out1\[23\] sky130_fd_sc_hd__dfxtp_1
XFILLER_42_15 VPWR VGND VPWR VGND sky130_ef_sc_hd__decap_12
XTAP_TAPCELL_ROW_101_1459 VGND VPWR sky130_fd_sc_hd__tapvpwrvgnd_1
X_5848_ _1678_ _1679_ _1680_ VGND VGND VPWR VPWR _1683_ sky130_fd_sc_hd__a21bo_1
X_5779_ _1470_ _1476_ _1469_ VGND VGND VPWR VPWR _1607_ sky130_fd_sc_hd__a21oi_1
XPHY_EDGE_ROW_33_Right_33 VGND VGND VPWR VPWR sky130_fd_sc_hd__decap_3
XFILLER_103_441 VGND VGND VPWR VPWR sky130_fd_sc_hd__decap_6
XFILLER_89_653 VPWR VGND VPWR VGND sky130_ef_sc_hd__decap_12
XTAP_TAPCELL_ROW_112_1599 VGND VPWR sky130_fd_sc_hd__tapvpwrvgnd_1
XFILLER_49_517 VGND VGND VPWR VPWR sky130_fd_sc_hd__decap_3
XFILLER_49_528 VGND VGND VPWR VPWR sky130_fd_sc_hd__decap_8
XFILLER_57_561 VPWR VGND VPWR VGND sky130_ef_sc_hd__decap_12
XFILLER_29_263 VGND VGND VPWR VPWR sky130_fd_sc_hd__fill_1
XFILLER_72_520 VPWR VGND VPWR VGND sky130_ef_sc_hd__decap_12
XFILLER_17_425 VGND VGND VPWR VPWR sky130_fd_sc_hd__decap_8
XPHY_EDGE_ROW_42_Right_42 VGND VGND VPWR VPWR sky130_fd_sc_hd__decap_3
XFILLER_83_55 VGND VGND VPWR VPWR sky130_fd_sc_hd__fill_1
XTAP_TAPCELL_ROW_67_1056 VGND VPWR sky130_fd_sc_hd__tapvpwrvgnd_1
XFILLER_17_447 VGND VGND VPWR VPWR sky130_fd_sc_hd__fill_1
XFILLER_72_575 VPWR VGND VPWR VGND sky130_ef_sc_hd__decap_12
XFILLER_32_417 VGND VGND VPWR VPWR sky130_fd_sc_hd__decap_3
XTAP_TAPCELL_ROW_80_1212 VGND VPWR sky130_fd_sc_hd__tapvpwrvgnd_1
XFILLER_13_653 VPWR VGND VPWR VGND sky130_ef_sc_hd__decap_12
XFILLER_16_82 VGND VGND VPWR VPWR sky130_fd_sc_hd__fill_2
XFILLER_12_141 VPWR VGND VPWR VGND sky130_ef_sc_hd__decap_12
XFILLER_8_101 VPWR VGND VPWR VGND sky130_ef_sc_hd__decap_12
XTAP_TAPCELL_ROW_30_607 VGND VPWR sky130_fd_sc_hd__tapvpwrvgnd_1
XFILLER_40_450 VGND VGND VPWR VPWR sky130_fd_sc_hd__decap_6
XFILLER_73_9 VGND VGND VPWR VPWR sky130_fd_sc_hd__decap_8
XPHY_EDGE_ROW_51_Right_51 VGND VGND VPWR VPWR sky130_fd_sc_hd__decap_3
XTAP_TAPCELL_ROW_10_375 VGND VPWR sky130_fd_sc_hd__tapvpwrvgnd_1
XTAP_TAPCELL_ROW_78_1185 VGND VPWR sky130_fd_sc_hd__tapvpwrvgnd_1
XTAP_TAPCELL_ROW_91_1341 VGND VPWR sky130_fd_sc_hd__tapvpwrvgnd_1
XFILLER_94_177 VGND VGND VPWR VPWR sky130_fd_sc_hd__decap_6
XPHY_EDGE_ROW_60_Right_60 VGND VGND VPWR VPWR sky130_fd_sc_hd__decap_3
XTAP_TAPCELL_ROW_38_707 VGND VPWR sky130_fd_sc_hd__tapvpwrvgnd_1
XFILLER_48_572 VPWR VGND VPWR VGND sky130_ef_sc_hd__decap_12
X_6820_ _2731_ _2741_ VGND VGND VPWR VPWR _2743_ sky130_fd_sc_hd__xnor2_1
XFILLER_63_597 VGND VGND VPWR VPWR sky130_fd_sc_hd__fill_1
XTAP_TAPCELL_ROW_18_464 VGND VPWR sky130_fd_sc_hd__tapvpwrvgnd_1
X_3963_ net164 net167 _2335_ VGND VGND VPWR VPWR _3153_ sky130_fd_sc_hd__a21bo_1
X_6751_ _2651_ _2655_ VGND VGND VPWR VPWR _2667_ sky130_fd_sc_hd__or2_1
X_3894_ _2996_ _3086_ net158 VGND VGND VPWR VPWR _3087_ sky130_fd_sc_hd__mux2_1
X_6682_ _2589_ _2590_ _2374_ _2377_ VGND VGND VPWR VPWR _2592_ sky130_fd_sc_hd__o211a_1
X_5702_ _1482_ _1521_ _1522_ VGND VGND VPWR VPWR _1523_ sky130_fd_sc_hd__and3_1
XFILLER_50_269 VGND VGND VPWR VPWR sky130_fd_sc_hd__decap_4
X_5633_ _1444_ _1445_ _1320_ _1324_ VGND VGND VPWR VPWR _1448_ sky130_fd_sc_hd__a211oi_1
XFILLER_12_29 VPWR VGND VPWR VGND sky130_ef_sc_hd__decap_12
X_5564_ _1369_ _1370_ _1243_ _1246_ VGND VGND VPWR VPWR _1372_ sky130_fd_sc_hd__a211o_1
X_4515_ _0234_ _0278_ _0279_ VGND VGND VPWR VPWR _0280_ sky130_fd_sc_hd__or3_1
XPHY_EDGE_ROW_103_Right_103 VGND VGND VPWR VPWR sky130_fd_sc_hd__decap_3
X_5495_ net375 net320 _1295_ _1296_ VGND VGND VPWR VPWR _1297_ sky130_fd_sc_hd__a22o_1
X_4446_ _0209_ _0210_ _0199_ VGND VGND VPWR VPWR _0212_ sky130_fd_sc_hd__a21o_1
X_4377_ _0144_ VGND VGND VPWR VPWR _0145_ sky130_fd_sc_hd__inv_2
XFILLER_86_601 VPWR VGND VPWR VGND sky130_ef_sc_hd__decap_12
XPHY_EDGE_ROW_13_Left_130 VGND VGND VPWR VPWR sky130_fd_sc_hd__decap_3
X_6116_ _0852_ _0917_ _1971_ _1973_ VGND VGND VPWR VPWR _1974_ sky130_fd_sc_hd__or4b_2
XFILLER_100_433 VPWR VGND VPWR VGND sky130_ef_sc_hd__decap_12
XFILLER_86_645 VPWR VGND VPWR VGND sky130_ef_sc_hd__decap_12
XFILLER_37_15 VPWR VGND VPWR VGND sky130_ef_sc_hd__decap_12
XFILLER_86_689 VGND VGND VPWR VPWR sky130_fd_sc_hd__decap_3
XFILLER_85_177 VGND VGND VPWR VPWR sky130_fd_sc_hd__decap_6
X_6047_ _1875_ _1896_ _1897_ VGND VGND VPWR VPWR _1899_ sky130_fd_sc_hd__and3_1
XFILLER_39_561 VPWR VGND VPWR VGND sky130_ef_sc_hd__decap_12
XFILLER_54_564 VPWR VGND VPWR VGND sky130_ef_sc_hd__decap_12
XFILLER_14_428 VGND VGND VPWR VPWR sky130_fd_sc_hd__fill_1
XFILLER_41_203 VGND VGND VPWR VPWR sky130_fd_sc_hd__fill_1
XFILLER_41_225 VPWR VGND VPWR VGND sky130_ef_sc_hd__decap_12
XFILLER_10_601 VPWR VGND VPWR VGND sky130_ef_sc_hd__decap_12
XFILLER_10_645 VPWR VGND VPWR VGND sky130_ef_sc_hd__decap_12
XFILLER_22_483 VPWR VGND VPWR VGND sky130_ef_sc_hd__decap_12
XFILLER_108_533 VPWR VGND VPWR VGND sky130_ef_sc_hd__decap_12
XFILLER_108_522 VGND VGND VPWR VPWR sky130_fd_sc_hd__decap_8
XFILLER_10_689 VGND VGND VPWR VPWR sky130_fd_sc_hd__decap_3
XFILLER_5_137 VGND VGND VPWR VPWR sky130_fd_sc_hd__decap_6
XTAP_TAPCELL_ROW_114_1617 VGND VPWR sky130_fd_sc_hd__tapvpwrvgnd_1
XFILLER_5_159 VGND VGND VPWR VPWR sky130_fd_sc_hd__decap_4
XFILLER_1_310 VGND VGND VPWR VPWR sky130_fd_sc_hd__fill_2
XFILLER_78_55 VGND VGND VPWR VPWR sky130_fd_sc_hd__decap_4
XFILLER_103_293 VGND VGND VPWR VPWR sky130_fd_sc_hd__fill_1
XFILLER_103_271 VGND VGND VPWR VPWR sky130_fd_sc_hd__decap_8
XFILLER_76_122 VGND VGND VPWR VPWR sky130_fd_sc_hd__decap_3
XFILLER_64_317 VGND VGND VPWR VPWR sky130_fd_sc_hd__decap_6
XFILLER_94_65 VPWR VGND VPWR VGND sky130_ef_sc_hd__decap_12
XFILLER_92_637 VGND VGND VPWR VPWR sky130_fd_sc_hd__decap_6
XFILLER_91_125 VGND VGND VPWR VPWR sky130_fd_sc_hd__fill_1
XFILLER_17_222 VGND VGND VPWR VPWR sky130_fd_sc_hd__fill_2
XFILLER_60_523 VGND VGND VPWR VPWR sky130_fd_sc_hd__fill_2
XFILLER_27_92 VPWR VGND VPWR VGND sky130_ef_sc_hd__decap_12
XTAP_TAPCELL_ROW_15_434 VGND VPWR sky130_fd_sc_hd__tapvpwrvgnd_1
XFILLER_60_589 VGND VGND VPWR VPWR sky130_fd_sc_hd__decap_8
XFILLER_13_461 VPWR VGND VPWR VGND sky130_ef_sc_hd__decap_12
XTAP_TAPCELL_ROW_43_765 VGND VPWR sky130_fd_sc_hd__tapvpwrvgnd_1
XFILLER_9_432 VPWR VGND VPWR VGND sky130_ef_sc_hd__decap_12
XFILLER_114_525 VGND VGND VPWR VPWR sky130_fd_sc_hd__decap_6
XFILLER_99_225 VPWR VGND VPWR VGND sky130_ef_sc_hd__decap_12
X_4300_ _alu_i0.Datapath_i.reg_0.reg_out1\[3\] net149 VGND VGND VPWR VPWR _0071_ sky130_fd_sc_hd__and2_1
XFILLER_5_671 VGND VGND VPWR VPWR sky130_fd_sc_hd__fill_1
X_5280_ net404 net317 net308 net412 VGND VGND VPWR VPWR _1063_ sky130_fd_sc_hd__a22o_1
XFILLER_114_569 VPWR VGND VPWR VGND sky130_ef_sc_hd__decap_12
XFILLER_87_409 VGND VGND VPWR VPWR sky130_fd_sc_hd__decap_4
X_4231_ _3402_ _0006_ _0007_ VGND VGND VPWR VPWR _alu_i0.Datapath_i.fu_alu_33673_33851.out1\[29\]
+ sky130_fd_sc_hd__or3_1
XFILLER_4_41 VPWR VGND VPWR VGND sky130_ef_sc_hd__decap_12
XFILLER_68_601 VPWR VGND VPWR VGND sky130_ef_sc_hd__decap_12
XFILLER_4_85 VGND VGND VPWR VPWR sky130_fd_sc_hd__decap_3
XFILLER_68_645 VPWR VGND VPWR VGND sky130_ef_sc_hd__decap_12
XFILLER_67_133 VGND VGND VPWR VPWR sky130_fd_sc_hd__fill_1
X_4162_ net134 _3332_ _3341_ _3342_ net128 VGND VGND VPWR VPWR _3343_ sky130_fd_sc_hd__o221a_1
X_4093_ net164 net440 _2073_ VGND VGND VPWR VPWR _3277_ sky130_fd_sc_hd__a21bo_1
XFILLER_67_177 VGND VGND VPWR VPWR sky130_fd_sc_hd__decap_8
XFILLER_36_597 VPWR VGND VPWR VGND sky130_ef_sc_hd__decap_12
X_4995_ net387 net215 _0751_ _0752_ VGND VGND VPWR VPWR _0753_ sky130_fd_sc_hd__a22o_1
X_6803_ _2718_ _2719_ _2720_ _2721_ VGND VGND VPWR VPWR _2724_ sky130_fd_sc_hd__o211a_1
XFILLER_23_225 VGND VGND VPWR VPWR sky130_fd_sc_hd__decap_3
XFILLER_23_236 VPWR VGND VPWR VGND sky130_ef_sc_hd__decap_12
X_3946_ _3041_ _3136_ net162 VGND VGND VPWR VPWR _3137_ sky130_fd_sc_hd__mux2_1
X_6734_ _2647_ _2648_ VGND VGND VPWR VPWR _2649_ sky130_fd_sc_hd__and2b_1
XFILLER_23_39 VPWR VGND VPWR VGND sky130_ef_sc_hd__decap_12
X_3877_ net232 _2885_ _3063_ net118 VGND VGND VPWR VPWR _3071_ sky130_fd_sc_hd__o211a_1
X_6665_ net174 net319 _2407_ _2406_ VGND VGND VPWR VPWR _2573_ sky130_fd_sc_hd__a31o_1
X_6596_ _2494_ _2496_ VGND VGND VPWR VPWR _2497_ sky130_fd_sc_hd__nor2_1
X_5616_ _1271_ _1427_ _1428_ VGND VGND VPWR VPWR _1429_ sky130_fd_sc_hd__and3_2
XFILLER_105_503 VGND VGND VPWR VPWR sky130_fd_sc_hd__fill_1
X_5547_ _1279_ _1290_ _1289_ VGND VGND VPWR VPWR _1354_ sky130_fd_sc_hd__a21o_1
XFILLER_105_536 VPWR VGND VPWR VGND sky130_ef_sc_hd__decap_12
XFILLER_2_107 VGND VGND VPWR VPWR sky130_fd_sc_hd__fill_2
X_5478_ _1276_ _1278_ VGND VGND VPWR VPWR _1279_ sky130_fd_sc_hd__xnor2_1
X_4429_ _0192_ _0193_ VGND VGND VPWR VPWR _0195_ sky130_fd_sc_hd__xor2_1
Xfanout422 net423 VGND VGND VPWR VPWR net422 sky130_fd_sc_hd__buf_2
Xfanout400 net28 VGND VGND VPWR VPWR net400 sky130_fd_sc_hd__buf_2
Xfanout411 net26 VGND VGND VPWR VPWR net411 sky130_fd_sc_hd__clkbuf_4
Xfanout455 net456 VGND VGND VPWR VPWR net455 sky130_fd_sc_hd__buf_2
Xfanout433 net434 VGND VGND VPWR VPWR net433 sky130_fd_sc_hd__clkbuf_4
Xfanout466 net467 VGND VGND VPWR VPWR net466 sky130_fd_sc_hd__clkbuf_4
Xfanout444 net15 VGND VGND VPWR VPWR net444 sky130_fd_sc_hd__buf_2
XFILLER_86_464 VGND VGND VPWR VPWR sky130_fd_sc_hd__decap_6
XFILLER_104_53 VPWR VGND VPWR VGND sky130_ef_sc_hd__decap_12
XFILLER_73_103 VGND VGND VPWR VPWR sky130_fd_sc_hd__decap_8
XFILLER_104_97 VPWR VGND VPWR VGND sky130_ef_sc_hd__decap_12
XFILLER_73_136 VGND VGND VPWR VPWR sky130_fd_sc_hd__fill_1
XFILLER_82_681 VGND VGND VPWR VPWR sky130_fd_sc_hd__decap_8
XTAP_TAPCELL_ROW_64_1015 VGND VPWR sky130_fd_sc_hd__tapvpwrvgnd_1
XFILLER_54_361 VGND VGND VPWR VPWR sky130_fd_sc_hd__decap_3
XFILLER_42_501 VGND VGND VPWR VPWR sky130_fd_sc_hd__decap_3
XFILLER_14_214 VGND VGND VPWR VPWR sky130_fd_sc_hd__decap_8
XFILLER_42_578 VGND VGND VPWR VPWR sky130_fd_sc_hd__decap_8
XTAP_TAPCELL_ROW_40_735 VGND VPWR sky130_fd_sc_hd__tapvpwrvgnd_1
XFILLER_22_280 VGND VGND VPWR VPWR sky130_fd_sc_hd__decap_4
XFILLER_10_475 VGND VGND VPWR VPWR sky130_fd_sc_hd__fill_1
XFILLER_108_352 VGND VGND VPWR VPWR sky130_fd_sc_hd__decap_8
XFILLER_108_330 VPWR VGND VPWR VGND sky130_ef_sc_hd__decap_12
XTAP_TAPCELL_ROW_20_492 VGND VPWR sky130_fd_sc_hd__tapvpwrvgnd_1
XTAP_TAPCELL_ROW_75_1155 VGND VPWR sky130_fd_sc_hd__tapvpwrvgnd_1
XFILLER_111_517 VPWR VGND VPWR VGND sky130_ef_sc_hd__decap_12
XFILLER_77_442 VGND VGND VPWR VPWR sky130_fd_sc_hd__decap_6
XFILLER_37_317 VPWR VGND VPWR VGND sky130_ef_sc_hd__decap_12
XTAP_TAPCELL_ROW_48_824 VGND VPWR sky130_fd_sc_hd__tapvpwrvgnd_1
XFILLER_49_177 VGND VGND VPWR VPWR sky130_fd_sc_hd__fill_2
XFILLER_92_445 VGND VGND VPWR VPWR sky130_fd_sc_hd__fill_1
XFILLER_92_489 VGND VGND VPWR VPWR sky130_fd_sc_hd__decap_6
XFILLER_52_309 VGND VGND VPWR VPWR sky130_fd_sc_hd__fill_1
XTAP_TAPCELL_ROW_86_1284 VGND VPWR sky130_fd_sc_hd__tapvpwrvgnd_1
XTAP_TAPCELL_ROW_28_592 VGND VPWR sky130_fd_sc_hd__tapvpwrvgnd_1
X_4780_ _0471_ _0473_ _0470_ VGND VGND VPWR VPWR _0541_ sky130_fd_sc_hd__o21ai_1
X_3800_ _2912_ _2996_ net158 VGND VGND VPWR VPWR _2997_ sky130_fd_sc_hd__mux2_1
X_3731_ net137 _2919_ net132 VGND VGND VPWR VPWR _2931_ sky130_fd_sc_hd__a21oi_1
X_3662_ net251 _1637_ net241 VGND VGND VPWR VPWR _2865_ sky130_fd_sc_hd__a21o_1
X_6450_ net413 net254 VGND VGND VPWR VPWR _2339_ sky130_fd_sc_hd__nand2_1
XFILLER_9_262 VGND VGND VPWR VPWR sky130_fd_sc_hd__decap_6
X_3593_ net285 net456 VGND VGND VPWR VPWR _2798_ sky130_fd_sc_hd__nand2b_1
X_5401_ _1142_ _1143_ _1193_ _1194_ VGND VGND VPWR VPWR _1195_ sky130_fd_sc_hd__nor4_1
X_6381_ _2261_ _2262_ _2066_ _2108_ VGND VGND VPWR VPWR _2264_ sky130_fd_sc_hd__o211a_1
X_5332_ _1017_ _1020_ VGND VGND VPWR VPWR _1119_ sky130_fd_sc_hd__nand2_1
XFILLER_114_344 VGND VGND VPWR VPWR sky130_fd_sc_hd__decap_6
X_5263_ net387 net192 VGND VGND VPWR VPWR _1044_ sky130_fd_sc_hd__nand2_1
XFILLER_87_228 VPWR VGND VPWR VGND sky130_ef_sc_hd__decap_12
X_5194_ _0956_ _0967_ VGND VGND VPWR VPWR _0969_ sky130_fd_sc_hd__xnor2_1
X_4214_ net22 net54 VGND VGND VPWR VPWR _3392_ sky130_fd_sc_hd__and2_1
X_4145_ _3240_ _3326_ net159 VGND VGND VPWR VPWR _3327_ sky130_fd_sc_hd__mux2_1
XFILLER_95_261 VGND VGND VPWR VPWR sky130_fd_sc_hd__decap_8
XFILLER_83_423 VGND VGND VPWR VPWR sky130_fd_sc_hd__decap_4
XFILLER_55_125 VPWR VGND VPWR VGND sky130_ef_sc_hd__decap_12
XFILLER_28_339 VGND VGND VPWR VPWR sky130_fd_sc_hd__fill_2
X_4076_ _3175_ _3260_ net161 VGND VGND VPWR VPWR _3261_ sky130_fd_sc_hd__mux2_1
XFILLER_83_489 VGND VGND VPWR VPWR sky130_fd_sc_hd__decap_3
XFILLER_64_681 VGND VGND VPWR VPWR sky130_fd_sc_hd__decap_8
XFILLER_24_512 VPWR VGND VPWR VGND sky130_ef_sc_hd__decap_12
XFILLER_36_350 VGND VGND VPWR VPWR sky130_fd_sc_hd__decap_3
XFILLER_70_139 VGND VGND VPWR VPWR sky130_fd_sc_hd__fill_1
XFILLER_34_27 VGND VGND VPWR VPWR sky130_fd_sc_hd__fill_1
X_4978_ net227 net312 net260 net240 VGND VGND VPWR VPWR _0736_ sky130_fd_sc_hd__a22o_1
XFILLER_24_589 VPWR VGND VPWR VGND sky130_ef_sc_hd__decap_12
X_3929_ _3029_ _3118_ _3119_ _3117_ VGND VGND VPWR VPWR _3120_ sky130_fd_sc_hd__o211a_1
X_6717_ _2397_ _2399_ _2629_ VGND VGND VPWR VPWR _2631_ sky130_fd_sc_hd__o21ai_1
X_6648_ _2552_ _2554_ VGND VGND VPWR VPWR _2555_ sky130_fd_sc_hd__nand2_1
X_6579_ _2263_ _2310_ _2479_ _2480_ VGND VGND VPWR VPWR _2481_ sky130_fd_sc_hd__o211a_1
XFILLER_59_24 VGND VGND VPWR VPWR sky130_fd_sc_hd__decap_4
XFILLER_3_449 VGND VGND VPWR VPWR sky130_fd_sc_hd__fill_1
XFILLER_59_57 VGND VGND VPWR VPWR sky130_fd_sc_hd__decap_3
XFILLER_59_35 VGND VGND VPWR VPWR sky130_fd_sc_hd__decap_6
Xfanout230 net59 VGND VGND VPWR VPWR net230 sky130_fd_sc_hd__clkbuf_4
Xfanout241 net242 VGND VGND VPWR VPWR net241 sky130_fd_sc_hd__buf_2
Xfanout252 net55 VGND VGND VPWR VPWR net252 sky130_fd_sc_hd__clkbuf_2
Xfanout274 net276 VGND VGND VPWR VPWR net274 sky130_fd_sc_hd__clkbuf_4
Xfanout263 net265 VGND VGND VPWR VPWR net263 sky130_fd_sc_hd__buf_2
XFILLER_101_561 VPWR VGND VPWR VGND sky130_ef_sc_hd__decap_12
Xfanout285 net288 VGND VGND VPWR VPWR net285 sky130_fd_sc_hd__clkbuf_4
XTAP_TAPCELL_ROW_70_1096 VGND VPWR sky130_fd_sc_hd__tapvpwrvgnd_1
Xfanout296 net297 VGND VGND VPWR VPWR net296 sky130_fd_sc_hd__buf_2
XFILLER_19_317 VGND VGND VPWR VPWR sky130_fd_sc_hd__fill_2
XFILLER_46_114 VPWR VGND VPWR VGND sky130_ef_sc_hd__decap_12
XFILLER_47_615 VGND VGND VPWR VPWR sky130_fd_sc_hd__fill_1
XFILLER_34_309 VGND VGND VPWR VPWR sky130_fd_sc_hd__decap_4
XFILLER_91_33 VPWR VGND VPWR VGND sky130_ef_sc_hd__decap_12
XTAP_TAPCELL_ROW_25_551 VGND VPWR sky130_fd_sc_hd__tapvpwrvgnd_1
XFILLER_91_99 VPWR VGND VPWR VGND sky130_ef_sc_hd__decap_12
XTAP_TAPCELL_ROW_53_893 VGND VPWR sky130_fd_sc_hd__tapvpwrvgnd_1
XFILLER_42_397 VGND VGND VPWR VPWR sky130_fd_sc_hd__decap_8
XTAP_TAPCELL_ROW_53_882 VGND VPWR sky130_fd_sc_hd__tapvpwrvgnd_1
XFILLER_30_559 VGND VGND VPWR VPWR sky130_fd_sc_hd__fill_1
XFILLER_10_250 VGND VGND VPWR VPWR sky130_fd_sc_hd__fill_2
XFILLER_6_243 VGND VGND VPWR VPWR sky130_fd_sc_hd__decap_8
XFILLER_97_526 VPWR VGND VPWR VGND sky130_ef_sc_hd__decap_12
XFILLER_111_325 VGND VGND VPWR VPWR sky130_fd_sc_hd__fill_1
XFILLER_84_209 VGND VGND VPWR VPWR sky130_fd_sc_hd__decap_4
XFILLER_49_90 VGND VGND VPWR VPWR sky130_fd_sc_hd__fill_1
XTAP_TAPCELL_ROW_88_1313 VGND VPWR sky130_fd_sc_hd__tapvpwrvgnd_1
XTAP_TAPCELL_ROW_88_1302 VGND VPWR sky130_fd_sc_hd__tapvpwrvgnd_1
XFILLER_65_434 VPWR VGND VPWR VGND sky130_ef_sc_hd__decap_12
XFILLER_37_147 VPWR VGND VPWR VGND sky130_ef_sc_hd__decap_12
XFILLER_53_629 VPWR VGND VPWR VGND sky130_ef_sc_hd__decap_12
X_5950_ _1644_ _1646_ _1791_ _1793_ VGND VGND VPWR VPWR _1794_ sky130_fd_sc_hd__a211oi_1
XFILLER_37_169 VGND VGND VPWR VPWR sky130_fd_sc_hd__decap_3
X_4901_ _1670_ _0659_ VGND VGND VPWR VPWR _0660_ sky130_fd_sc_hd__xnor2_1
XFILLER_46_681 VGND VGND VPWR VPWR sky130_fd_sc_hd__decap_8
XFILLER_52_139 VGND VGND VPWR VPWR sky130_fd_sc_hd__fill_1
XFILLER_61_673 VPWR VGND VPWR VGND sky130_ef_sc_hd__decap_12
X_5881_ _1716_ _1717_ VGND VGND VPWR VPWR _1719_ sky130_fd_sc_hd__xnor2_1
X_4832_ _0578_ _0590_ _0591_ VGND VGND VPWR VPWR _0592_ sky130_fd_sc_hd__and3_1
X_4763_ _0521_ _0522_ _0504_ VGND VGND VPWR VPWR _0524_ sky130_fd_sc_hd__a21o_1
XFILLER_21_559 VGND VGND VPWR VPWR sky130_fd_sc_hd__fill_1
X_4694_ _0453_ _0454_ _0383_ _0385_ VGND VGND VPWR VPWR _0456_ sky130_fd_sc_hd__o211a_1
XTAP_TAPCELL_ROW_99_1442 VGND VPWR sky130_fd_sc_hd__tapvpwrvgnd_1
X_3714_ _2498_ _2575_ _2586_ _2608_ net155 net162 VGND VGND VPWR VPWR _2915_ sky130_fd_sc_hd__mux4_1
X_6502_ _2231_ _2233_ _2230_ VGND VGND VPWR VPWR _2396_ sky130_fd_sc_hd__o21ba_1
XFILLER_107_609 VGND VGND VPWR VPWR sky130_fd_sc_hd__decap_6
X_6433_ _1430_ _2126_ _2124_ VGND VGND VPWR VPWR _2321_ sky130_fd_sc_hd__o21ai_2
XFILLER_106_108 VPWR VGND VPWR VGND sky130_ef_sc_hd__decap_12
X_3645_ _2845_ _2847_ VGND VGND VPWR VPWR _2848_ sky130_fd_sc_hd__or2_1
XFILLER_20_29 VPWR VGND VPWR VGND sky130_ef_sc_hd__decap_12
XFILLER_115_653 VPWR VGND VPWR VGND sky130_ef_sc_hd__decap_12
X_3576_ _2608_ _2619_ net162 VGND VGND VPWR VPWR _2630_ sky130_fd_sc_hd__mux2_1
X_6364_ _2243_ _2244_ VGND VGND VPWR VPWR _2245_ sky130_fd_sc_hd__nor2_1
X_5315_ _1099_ VGND VGND VPWR VPWR _1100_ sky130_fd_sc_hd__inv_2
X_6295_ _2168_ _2169_ VGND VGND VPWR VPWR _2170_ sky130_fd_sc_hd__nand2_1
X_5246_ _1013_ _1023_ _1024_ VGND VGND VPWR VPWR _1025_ sky130_fd_sc_hd__and3_2
XPHY_EDGE_ROW_89_Right_89 VGND VGND VPWR VPWR sky130_fd_sc_hd__decap_3
XFILLER_29_27 VPWR VGND VPWR VGND sky130_ef_sc_hd__decap_12
X_5177_ _0946_ _0947_ _0948_ VGND VGND VPWR VPWR _0951_ sky130_fd_sc_hd__nand3_1
XFILLER_68_283 VGND VGND VPWR VPWR sky130_fd_sc_hd__fill_2
XFILLER_83_242 VGND VGND VPWR VPWR sky130_fd_sc_hd__fill_2
X_4128_ net131 _3285_ _3305_ _3310_ VGND VGND VPWR VPWR _3311_ sky130_fd_sc_hd__a211o_1
XFILLER_83_275 VGND VGND VPWR VPWR sky130_fd_sc_hd__decap_4
X_4059_ _3238_ _3243_ _3244_ _2884_ net117 VGND VGND VPWR VPWR _alu_i0.Datapath_i.fu_alu_33673_33851.out1\[21\]
+ sky130_fd_sc_hd__a32o_1
XFILLER_16_309 VPWR VGND VPWR VGND sky130_ef_sc_hd__decap_12
XFILLER_45_15 VGND VGND VPWR VPWR sky130_fd_sc_hd__decap_4
XPHY_EDGE_ROW_98_Right_98 VGND VGND VPWR VPWR sky130_fd_sc_hd__decap_3
XFILLER_12_504 VGND VGND VPWR VPWR sky130_fd_sc_hd__fill_2
XTAP_TAPCELL_ROW_22_510 VGND VPWR sky130_fd_sc_hd__tapvpwrvgnd_1
XFILLER_24_386 VGND VGND VPWR VPWR sky130_fd_sc_hd__decap_6
XFILLER_8_519 VGND VGND VPWR VPWR sky130_fd_sc_hd__fill_2
XTAP_TAPCELL_ROW_22_521 VGND VPWR sky130_fd_sc_hd__tapvpwrvgnd_1
XTAP_TAPCELL_ROW_50_852 VGND VPWR sky130_fd_sc_hd__tapvpwrvgnd_1
XFILLER_105_130 VGND VGND VPWR VPWR sky130_fd_sc_hd__decap_6
XFILLER_79_515 VGND VGND VPWR VPWR sky130_fd_sc_hd__decap_8
XTAP_TAPCELL_ROW_72_1114 VGND VPWR sky130_fd_sc_hd__tapvpwrvgnd_1
XPHY_EDGE_ROW_5_Left_122 VGND VGND VPWR VPWR sky130_fd_sc_hd__decap_3
XFILLER_79_559 VGND VGND VPWR VPWR sky130_fd_sc_hd__fill_1
XFILLER_101_391 VGND VGND VPWR VPWR sky130_fd_sc_hd__fill_1
XFILLER_59_294 VPWR VGND VPWR VGND sky130_ef_sc_hd__decap_12
XTAP_TAPCELL_ROW_58_952 VGND VPWR sky130_fd_sc_hd__tapvpwrvgnd_1
XFILLER_74_275 VGND VGND VPWR VPWR sky130_fd_sc_hd__fill_1
XFILLER_74_253 VGND VGND VPWR VPWR sky130_fd_sc_hd__decap_8
XFILLER_35_629 VPWR VGND VPWR VGND sky130_ef_sc_hd__decap_12
XFILLER_74_297 VGND VGND VPWR VPWR sky130_fd_sc_hd__fill_2
XFILLER_62_426 VPWR VGND VPWR VGND sky130_ef_sc_hd__decap_12
XFILLER_28_681 VGND VGND VPWR VPWR sky130_fd_sc_hd__decap_8
XTAP_TAPCELL_ROW_83_1243 VGND VPWR sky130_fd_sc_hd__tapvpwrvgnd_1
XFILLER_15_331 VGND VGND VPWR VPWR sky130_fd_sc_hd__decap_4
XFILLER_43_673 VPWR VGND VPWR VGND sky130_ef_sc_hd__decap_12
XFILLER_30_389 VGND VGND VPWR VPWR sky130_fd_sc_hd__decap_8
XFILLER_7_541 VPWR VGND VPWR VGND sky130_ef_sc_hd__decap_12
XFILLER_7_585 VPWR VGND VPWR VGND sky130_ef_sc_hd__decap_12
X_3430_ net68 _1026_ VGND VGND VPWR VPWR _1037_ sky130_fd_sc_hd__and2_1
XFILLER_112_601 VPWR VGND VPWR VGND sky130_ef_sc_hd__decap_12
XFILLER_97_301 VPWR VGND VPWR VGND sky130_ef_sc_hd__decap_12
XTAP_TAPCELL_ROW_94_1383 VGND VPWR sky130_fd_sc_hd__tapvpwrvgnd_1
XFILLER_111_111 VGND VGND VPWR VPWR sky130_fd_sc_hd__fill_1
X_5100_ _0865_ _0866_ _0847_ VGND VGND VPWR VPWR _0867_ sky130_fd_sc_hd__a21o_1
X_6080_ _1929_ _1930_ _1932_ VGND VGND VPWR VPWR _1935_ sky130_fd_sc_hd__a21oi_1
XFILLER_32_3 VPWR VGND VPWR VGND sky130_ef_sc_hd__decap_12
XFILLER_112_645 VPWR VGND VPWR VGND sky130_ef_sc_hd__decap_12
XFILLER_111_144 VGND VGND VPWR VPWR sky130_fd_sc_hd__fill_1
X_5031_ _0702_ _0791_ VGND VGND VPWR VPWR _0792_ sky130_fd_sc_hd__xnor2_1
XFILLER_112_689 VGND VGND VPWR VPWR sky130_fd_sc_hd__decap_3
XPHY_EDGE_ROW_69_Left_186 VGND VGND VPWR VPWR sky130_fd_sc_hd__decap_3
XTAP_TAPCELL_ROW_0_238 VGND VPWR sky130_fd_sc_hd__tapvpwrvgnd_1
XTAP_TAPCELL_ROW_0_249 VGND VPWR sky130_fd_sc_hd__tapvpwrvgnd_1
XFILLER_25_139 VPWR VGND VPWR VGND sky130_ef_sc_hd__decap_12
X_5933_ net360 net429 net314 net305 VGND VGND VPWR VPWR _1775_ sky130_fd_sc_hd__nand4_1
XFILLER_80_278 VGND VGND VPWR VPWR sky130_fd_sc_hd__fill_1
XTAP_TAPCELL_ROW_36_679 VGND VPWR sky130_fd_sc_hd__tapvpwrvgnd_1
X_5864_ _1696_ _1697_ _1519_ _1521_ VGND VGND VPWR VPWR _1700_ sky130_fd_sc_hd__o211a_1
X_4815_ _0562_ _0573_ VGND VGND VPWR VPWR _0575_ sky130_fd_sc_hd__xnor2_1
XTAP_TAPCELL_ROW_103_1490 VGND VPWR sky130_fd_sc_hd__tapvpwrvgnd_1
XFILLER_21_389 VGND VGND VPWR VPWR sky130_fd_sc_hd__decap_3
X_5795_ _1490_ _1491_ _1489_ VGND VGND VPWR VPWR _1624_ sky130_fd_sc_hd__o21bai_1
X_4746_ net409 net195 _0410_ _0409_ VGND VGND VPWR VPWR _0507_ sky130_fd_sc_hd__a31o_1
XFILLER_31_39 VPWR VGND VPWR VGND sky130_ef_sc_hd__decap_12
X_4677_ net401 net393 net210 net202 VGND VGND VPWR VPWR _0439_ sky130_fd_sc_hd__nand4_1
XFILLER_107_417 VPWR VGND VPWR VGND sky130_ef_sc_hd__decap_12
XPHY_EDGE_ROW_78_Left_195 VGND VGND VPWR VPWR sky130_fd_sc_hd__decap_3
X_3628_ net378 net371 net363 net431 net354 net285 VGND VGND VPWR VPWR _2832_ sky130_fd_sc_hd__mux4_1
X_6416_ _2282_ _2300_ _2301_ VGND VGND VPWR VPWR _2302_ sky130_fd_sc_hd__nand3_2
XFILLER_115_461 VPWR VGND VPWR VGND sky130_ef_sc_hd__decap_12
X_6347_ _2224_ _2225_ VGND VGND VPWR VPWR _2227_ sky130_fd_sc_hd__nor2_1
X_3559_ net153 _2368_ _2434_ net117 VGND VGND VPWR VPWR _2445_ sky130_fd_sc_hd__o211a_1
XTAP_TAPCELL_ROW_8_349 VGND VPWR sky130_fd_sc_hd__tapvpwrvgnd_1
X_6278_ _1939_ _1941_ _2149_ _2151_ VGND VGND VPWR VPWR _2152_ sky130_fd_sc_hd__a211oi_1
X_5229_ _1002_ _1003_ _1005_ VGND VGND VPWR VPWR _1007_ sky130_fd_sc_hd__a21oi_1
XFILLER_56_253 VPWR VGND VPWR VGND sky130_ef_sc_hd__decap_12
XTAP_TAPCELL_ROW_55_911 VGND VPWR sky130_fd_sc_hd__tapvpwrvgnd_1
XFILLER_17_629 VPWR VGND VPWR VGND sky130_ef_sc_hd__decap_12
XTAP_TAPCELL_ROW_106_1519 VGND VPWR sky130_fd_sc_hd__tapvpwrvgnd_1
XFILLER_56_286 VPWR VGND VPWR VGND sky130_ef_sc_hd__decap_12
XFILLER_112_53 VPWR VGND VPWR VGND sky130_ef_sc_hd__decap_12
XFILLER_112_97 VPWR VGND VPWR VGND sky130_ef_sc_hd__decap_12
XFILLER_25_673 VPWR VGND VPWR VGND sky130_ef_sc_hd__decap_12
XFILLER_40_643 VGND VGND VPWR VPWR sky130_fd_sc_hd__fill_1
XFILLER_12_356 VGND VGND VPWR VPWR sky130_fd_sc_hd__decap_8
XFILLER_4_533 VPWR VGND VPWR VGND sky130_ef_sc_hd__decap_12
XFILLER_106_472 VGND VGND VPWR VPWR sky130_fd_sc_hd__decap_4
XFILLER_79_312 VPWR VGND VPWR VGND sky130_ef_sc_hd__decap_12
XFILLER_97_98 VPWR VGND VPWR VGND sky130_ef_sc_hd__decap_12
XFILLER_79_345 VPWR VGND VPWR VGND sky130_ef_sc_hd__decap_12
XFILLER_94_326 VPWR VGND VPWR VGND sky130_ef_sc_hd__decap_12
XFILLER_79_389 VGND VGND VPWR VPWR sky130_fd_sc_hd__decap_3
XFILLER_94_359 VGND VGND VPWR VPWR sky130_fd_sc_hd__fill_1
XFILLER_75_573 VPWR VGND VPWR VGND sky130_ef_sc_hd__decap_12
XFILLER_62_223 VPWR VGND VPWR VGND sky130_ef_sc_hd__decap_12
XFILLER_62_212 VGND VGND VPWR VPWR sky130_fd_sc_hd__fill_2
XFILLER_62_201 VGND VGND VPWR VPWR sky130_fd_sc_hd__fill_1
XFILLER_22_109 VPWR VGND VPWR VGND sky130_ef_sc_hd__decap_12
XTAP_TAPCELL_ROW_33_649 VGND VPWR sky130_fd_sc_hd__tapvpwrvgnd_1
X_4600_ _0359_ _0360_ _0361_ VGND VGND VPWR VPWR _0363_ sky130_fd_sc_hd__a21o_1
XFILLER_30_153 VGND VGND VPWR VPWR sky130_fd_sc_hd__fill_1
XFILLER_31_665 VGND VGND VPWR VPWR sky130_fd_sc_hd__decap_6
XTAP_TAPCELL_ROW_96_1401 VGND VPWR sky130_fd_sc_hd__tapvpwrvgnd_1
X_5580_ net395 net302 VGND VGND VPWR VPWR _1390_ sky130_fd_sc_hd__nand2_1
XFILLER_30_197 VPWR VGND VPWR VGND sky130_ef_sc_hd__decap_12
X_4531_ _0252_ _0253_ _0266_ _0265_ VGND VGND VPWR VPWR _0295_ sky130_fd_sc_hd__a31o_1
X_4462_ _0224_ _0225_ _0187_ VGND VGND VPWR VPWR _0228_ sky130_fd_sc_hd__o21ai_1
XFILLER_7_393 VGND VGND VPWR VPWR sky130_fd_sc_hd__fill_2
X_6201_ _2063_ _2064_ _1899_ VGND VGND VPWR VPWR _2067_ sky130_fd_sc_hd__a21oi_1
X_3413_ net446 VGND VGND VPWR VPWR _0852_ sky130_fd_sc_hd__inv_2
X_4393_ _0128_ _0131_ VGND VGND VPWR VPWR _0160_ sky130_fd_sc_hd__nand2_1
XFILLER_98_643 VGND VGND VPWR VPWR sky130_fd_sc_hd__fill_1
XFILLER_58_507 VGND VGND VPWR VPWR sky130_fd_sc_hd__fill_2
XTAP_TAPCELL_ROW_5_308 VGND VPWR sky130_fd_sc_hd__tapvpwrvgnd_1
X_6132_ _1792_ _1795_ _1989_ _1991_ VGND VGND VPWR VPWR _1992_ sky130_fd_sc_hd__a211oi_2
XFILLER_112_475 VGND VGND VPWR VPWR sky130_fd_sc_hd__fill_1
XFILLER_85_315 VGND VGND VPWR VPWR sky130_fd_sc_hd__decap_3
X_6063_ _1912_ _1913_ _1914_ VGND VGND VPWR VPWR _1916_ sky130_fd_sc_hd__a21o_1
XFILLER_100_637 VGND VGND VPWR VPWR sky130_fd_sc_hd__decap_6
X_5014_ _0770_ _0771_ _0676_ _0679_ VGND VGND VPWR VPWR _0773_ sky130_fd_sc_hd__o211a_1
XFILLER_85_337 VGND VGND VPWR VPWR sky130_fd_sc_hd__decap_4
XFILLER_38_253 VPWR VGND VPWR VGND sky130_ef_sc_hd__decap_12
XFILLER_26_415 VGND VGND VPWR VPWR sky130_fd_sc_hd__decap_4
XFILLER_81_543 VGND VGND VPWR VPWR sky130_fd_sc_hd__fill_2
XFILLER_81_598 VGND VGND VPWR VPWR sky130_fd_sc_hd__fill_1
X_5916_ _1610_ _1754_ _1755_ VGND VGND VPWR VPWR _1756_ sky130_fd_sc_hd__and3_1
X_6896_ net182 _alu_i0.Datapath_i.fu_alu_33673_33851.out1\[22\] VGND VGND VPWR VPWR
+ _alu_i0.Datapath_i.reg_0.reg_out1\[22\] sky130_fd_sc_hd__dfxtp_1
XFILLER_22_643 VGND VGND VPWR VPWR sky130_fd_sc_hd__fill_1
XFILLER_34_481 VGND VGND VPWR VPWR sky130_fd_sc_hd__fill_1
X_5847_ _1680_ _1679_ _1678_ VGND VGND VPWR VPWR _1682_ sky130_fd_sc_hd__nand3b_1
XFILLER_42_27 VGND VGND VPWR VPWR sky130_fd_sc_hd__fill_1
XPHY_EDGE_ROW_86_Left_203 VGND VGND VPWR VPWR sky130_fd_sc_hd__decap_3
X_5778_ _1598_ _1603_ VGND VGND VPWR VPWR _1606_ sky130_fd_sc_hd__xnor2_1
X_4729_ net289 net311 VGND VGND VPWR VPWR _0490_ sky130_fd_sc_hd__nand2_1
XFILLER_107_236 VGND VGND VPWR VPWR sky130_fd_sc_hd__decap_6
XFILLER_107_225 VGND VGND VPWR VPWR sky130_fd_sc_hd__fill_1
XFILLER_107_247 VPWR VGND VPWR VGND sky130_ef_sc_hd__decap_12
XFILLER_115_291 VPWR VGND VPWR VGND sky130_ef_sc_hd__decap_12
XFILLER_89_665 VGND VGND VPWR VPWR sky130_fd_sc_hd__decap_6
XFILLER_107_97 VPWR VGND VPWR VGND sky130_ef_sc_hd__decap_12
XPHY_EDGE_ROW_95_Left_212 VGND VGND VPWR VPWR sky130_fd_sc_hd__decap_3
XFILLER_88_197 VPWR VGND VPWR VGND sky130_ef_sc_hd__decap_12
XFILLER_57_573 VPWR VGND VPWR VGND sky130_ef_sc_hd__decap_12
XFILLER_57_551 VGND VGND VPWR VPWR sky130_fd_sc_hd__fill_1
XFILLER_29_231 VGND VGND VPWR VPWR sky130_fd_sc_hd__fill_1
XTAP_TAPCELL_ROW_67_1057 VGND VPWR sky130_fd_sc_hd__tapvpwrvgnd_1
XFILLER_72_587 VGND VGND VPWR VPWR sky130_fd_sc_hd__fill_1
XFILLER_16_61 VGND VGND VPWR VPWR sky130_fd_sc_hd__fill_1
XTAP_TAPCELL_ROW_80_1213 VGND VPWR sky130_fd_sc_hd__tapvpwrvgnd_1
XFILLER_12_153 VPWR VGND VPWR VGND sky130_ef_sc_hd__decap_12
XFILLER_13_665 VGND VGND VPWR VPWR sky130_fd_sc_hd__decap_6
XTAP_TAPCELL_ROW_30_608 VGND VPWR sky130_fd_sc_hd__tapvpwrvgnd_1
XFILLER_8_113 VPWR VGND VPWR VGND sky130_ef_sc_hd__decap_12
XFILLER_12_197 VPWR VGND VPWR VGND sky130_ef_sc_hd__decap_12
XTAP_TAPCELL_ROW_10_376 VGND VPWR sky130_fd_sc_hd__tapvpwrvgnd_1
XTAP_TAPCELL_ROW_78_1186 VGND VPWR sky130_fd_sc_hd__tapvpwrvgnd_1
XFILLER_4_363 VGND VGND VPWR VPWR sky130_fd_sc_hd__fill_1
XTAP_TAPCELL_ROW_91_1342 VGND VPWR sky130_fd_sc_hd__tapvpwrvgnd_1
XFILLER_67_315 VGND VGND VPWR VPWR sky130_fd_sc_hd__fill_1
XFILLER_67_337 VGND VGND VPWR VPWR sky130_fd_sc_hd__fill_2
XFILLER_82_307 VGND VGND VPWR VPWR sky130_fd_sc_hd__fill_1
XTAP_TAPCELL_ROW_38_708 VGND VPWR sky130_fd_sc_hd__tapvpwrvgnd_1
XFILLER_48_584 VGND VGND VPWR VPWR sky130_fd_sc_hd__decap_4
XTAP_TAPCELL_ROW_18_465 VGND VPWR sky130_fd_sc_hd__tapvpwrvgnd_1
XFILLER_35_267 VPWR VGND VPWR VGND sky130_ef_sc_hd__decap_12
X_6750_ net147 _2664_ _2665_ _2666_ VGND VGND VPWR VPWR net100 sky130_fd_sc_hd__a31o_1
X_3962_ net140 _3150_ _3151_ _3148_ VGND VGND VPWR VPWR _3152_ sky130_fd_sc_hd__o31a_1
X_5701_ _1518_ _1520_ _1425_ _1428_ VGND VGND VPWR VPWR _1522_ sky130_fd_sc_hd__o211ai_1
X_3893_ net220 net261 net312 net385 net350 net279 VGND VGND VPWR VPWR _3086_ sky130_fd_sc_hd__mux4_1
X_6681_ _2374_ _2377_ _2589_ _2590_ VGND VGND VPWR VPWR _2591_ sky130_fd_sc_hd__a211oi_1
X_5632_ _1446_ VGND VGND VPWR VPWR _1447_ sky130_fd_sc_hd__inv_2
X_5563_ _1243_ _1246_ _1369_ _1370_ VGND VGND VPWR VPWR _1371_ sky130_fd_sc_hd__o211ai_4
X_4514_ _0276_ _0277_ _0222_ VGND VGND VPWR VPWR _0279_ sky130_fd_sc_hd__a21oi_1
X_5494_ net395 net388 net315 net307 VGND VGND VPWR VPWR _1296_ sky130_fd_sc_hd__nand4_1
XFILLER_104_217 VGND VGND VPWR VPWR sky130_fd_sc_hd__fill_2
X_4445_ _0199_ _0209_ _0210_ VGND VGND VPWR VPWR _0211_ sky130_fd_sc_hd__nand3_1
X_4376_ _0142_ _0143_ VGND VGND VPWR VPWR _0144_ sky130_fd_sc_hd__nand2_1
XFILLER_112_261 VGND VGND VPWR VPWR sky130_fd_sc_hd__fill_1
XFILLER_86_613 VPWR VGND VPWR VGND sky130_ef_sc_hd__decap_12
X_6115_ net449 net205 net198 net462 VGND VGND VPWR VPWR _1973_ sky130_fd_sc_hd__a22o_1
XFILLER_86_657 VPWR VGND VPWR VGND sky130_ef_sc_hd__decap_12
XFILLER_100_445 VPWR VGND VPWR VGND sky130_ef_sc_hd__decap_12
X_6046_ _1894_ _1895_ _1877_ VGND VGND VPWR VPWR _1897_ sky130_fd_sc_hd__a21o_1
XFILLER_37_27 VPWR VGND VPWR VGND sky130_ef_sc_hd__decap_12
XFILLER_54_521 VGND VGND VPWR VPWR sky130_fd_sc_hd__decap_4
XFILLER_39_573 VPWR VGND VPWR VGND sky130_ef_sc_hd__decap_12
XFILLER_81_373 VGND VGND VPWR VPWR sky130_fd_sc_hd__fill_1
XFILLER_54_576 VPWR VGND VPWR VGND sky130_ef_sc_hd__decap_12
XFILLER_41_237 VPWR VGND VPWR VGND sky130_ef_sc_hd__decap_12
X_6879_ net180 _alu_i0.Datapath_i.fu_alu_33673_33851.out1\[5\] VGND VGND VPWR VPWR
+ _alu_i0.Datapath_i.reg_0.reg_out1\[5\] sky130_fd_sc_hd__dfxtp_1
XFILLER_10_613 VPWR VGND VPWR VGND sky130_ef_sc_hd__decap_12
XFILLER_22_495 VPWR VGND VPWR VGND sky130_ef_sc_hd__decap_12
XFILLER_10_657 VPWR VGND VPWR VGND sky130_ef_sc_hd__decap_12
XTAP_TAPCELL_ROW_114_1618 VGND VPWR sky130_fd_sc_hd__tapvpwrvgnd_1
XFILLER_108_545 VPWR VGND VPWR VGND sky130_ef_sc_hd__decap_12
XFILLER_108_589 VPWR VGND VPWR VGND sky130_ef_sc_hd__decap_12
XFILLER_110_209 VGND VGND VPWR VPWR sky130_fd_sc_hd__decap_6
XFILLER_78_78 VGND VGND VPWR VPWR sky130_fd_sc_hd__fill_1
XFILLER_76_134 VGND VGND VPWR VPWR sky130_fd_sc_hd__decap_6
XFILLER_1_388 VGND VGND VPWR VPWR sky130_fd_sc_hd__decap_4
XFILLER_49_337 VPWR VGND VPWR VGND sky130_ef_sc_hd__decap_12
XFILLER_94_77 VGND VGND VPWR VPWR sky130_fd_sc_hd__decap_6
XFILLER_57_381 VGND VGND VPWR VPWR sky130_fd_sc_hd__decap_8
XFILLER_45_532 VGND VGND VPWR VPWR sky130_fd_sc_hd__decap_8
XFILLER_72_373 VGND VGND VPWR VPWR sky130_fd_sc_hd__fill_2
XFILLER_72_362 VGND VGND VPWR VPWR sky130_fd_sc_hd__fill_2
XFILLER_45_587 VGND VGND VPWR VPWR sky130_fd_sc_hd__fill_1
XTAP_TAPCELL_ROW_15_435 VGND VPWR sky130_fd_sc_hd__tapvpwrvgnd_1
XFILLER_32_226 VGND VGND VPWR VPWR sky130_fd_sc_hd__fill_1
XFILLER_32_237 VPWR VGND VPWR VGND sky130_ef_sc_hd__decap_12
XTAP_TAPCELL_ROW_43_766 VGND VPWR sky130_fd_sc_hd__tapvpwrvgnd_1
XFILLER_9_444 VGND VGND VPWR VPWR sky130_fd_sc_hd__decap_4
XFILLER_99_237 VPWR VGND VPWR VGND sky130_ef_sc_hd__decap_12
X_4230_ _2882_ _3308_ _3134_ _3068_ VGND VGND VPWR VPWR _0007_ sky130_fd_sc_hd__a2bb2o_1
XFILLER_68_613 VGND VGND VPWR VPWR sky130_fd_sc_hd__fill_1
XFILLER_4_53 VPWR VGND VPWR VGND sky130_ef_sc_hd__decap_12
X_4161_ net142 _3331_ net134 VGND VGND VPWR VPWR _3342_ sky130_fd_sc_hd__o21ai_1
XFILLER_68_657 VPWR VGND VPWR VGND sky130_ef_sc_hd__decap_12
X_4092_ net131 _3269_ _3275_ _1539_ VGND VGND VPWR VPWR _3276_ sky130_fd_sc_hd__a211o_1
XFILLER_91_671 VGND VGND VPWR VPWR sky130_fd_sc_hd__fill_1
X_6802_ _2501_ _2722_ VGND VGND VPWR VPWR _2723_ sky130_fd_sc_hd__xor2_1
XFILLER_51_513 VGND VGND VPWR VPWR sky130_fd_sc_hd__fill_2
X_4994_ net434 net210 net202 net366 VGND VGND VPWR VPWR _0752_ sky130_fd_sc_hd__a22o_1
XFILLER_51_546 VPWR VGND VPWR VGND sky130_ef_sc_hd__decap_12
X_3945_ net170 net176 net220 net261 net350 net279 VGND VGND VPWR VPWR _3136_ sky130_fd_sc_hd__mux4_1
X_6733_ _2473_ _2476_ VGND VGND VPWR VPWR _2648_ sky130_fd_sc_hd__nand2_1
XFILLER_23_248 VPWR VGND VPWR VGND sky130_ef_sc_hd__decap_12
XFILLER_31_270 VGND VGND VPWR VPWR sky130_fd_sc_hd__decap_8
X_6664_ _2570_ _2571_ VGND VGND VPWR VPWR _2572_ sky130_fd_sc_hd__or2_1
X_3876_ net132 _3051_ _3068_ net122 VGND VGND VPWR VPWR _3070_ sky130_fd_sc_hd__a22o_1
XFILLER_31_281 VGND VGND VPWR VPWR sky130_fd_sc_hd__decap_6
X_5615_ _1412_ _1425_ _1426_ VGND VGND VPWR VPWR _1428_ sky130_fd_sc_hd__nand3_1
X_6595_ net419 net413 net253 net53 VGND VGND VPWR VPWR _2496_ sky130_fd_sc_hd__and4_1
X_5546_ _2073_ _1350_ VGND VGND VPWR VPWR _1352_ sky130_fd_sc_hd__xor2_1
XFILLER_3_609 VGND VGND VPWR VPWR sky130_fd_sc_hd__decap_6
X_5477_ net259 net192 VGND VGND VPWR VPWR _1278_ sky130_fd_sc_hd__nand2_1
X_4428_ _0192_ _0193_ VGND VGND VPWR VPWR _0194_ sky130_fd_sc_hd__nand2_1
XFILLER_105_548 VPWR VGND VPWR VGND sky130_ef_sc_hd__decap_12
Xfanout401 net402 VGND VGND VPWR VPWR net401 sky130_fd_sc_hd__buf_2
Xfanout423 net426 VGND VGND VPWR VPWR net423 sky130_fd_sc_hd__clkbuf_4
Xfanout412 net26 VGND VGND VPWR VPWR net412 sky130_fd_sc_hd__clkbuf_2
X_4359_ _0094_ _0096_ _0095_ VGND VGND VPWR VPWR _0127_ sky130_fd_sc_hd__o21bai_1
XFILLER_86_421 VGND VGND VPWR VPWR sky130_fd_sc_hd__decap_6
XFILLER_86_410 VGND VGND VPWR VPWR sky130_fd_sc_hd__decap_8
Xfanout456 net459 VGND VGND VPWR VPWR net456 sky130_fd_sc_hd__clkbuf_4
Xfanout434 net2 VGND VGND VPWR VPWR net434 sky130_fd_sc_hd__clkbuf_4
Xfanout445 net447 VGND VGND VPWR VPWR net445 sky130_fd_sc_hd__buf_2
Xfanout467 net10 VGND VGND VPWR VPWR net467 sky130_fd_sc_hd__buf_2
XFILLER_46_307 VGND VGND VPWR VPWR sky130_fd_sc_hd__fill_1
X_6029_ net367 net297 net293 net374 VGND VGND VPWR VPWR _1879_ sky130_fd_sc_hd__a22o_1
XFILLER_104_65 VPWR VGND VPWR VGND sky130_ef_sc_hd__decap_12
XTAP_TAPCELL_ROW_64_1016 VGND VPWR sky130_fd_sc_hd__tapvpwrvgnd_1
XFILLER_42_524 VGND VGND VPWR VPWR sky130_fd_sc_hd__fill_1
XTAP_TAPCELL_ROW_40_736 VGND VPWR sky130_fd_sc_hd__tapvpwrvgnd_1
XFILLER_13_51 VGND VGND VPWR VPWR sky130_fd_sc_hd__decap_4
XFILLER_108_342 VGND VGND VPWR VPWR sky130_fd_sc_hd__decap_6
XFILLER_6_447 VGND VGND VPWR VPWR sky130_fd_sc_hd__decap_3
XTAP_TAPCELL_ROW_20_493 VGND VPWR sky130_fd_sc_hd__tapvpwrvgnd_1
XFILLER_89_55 VGND VGND VPWR VPWR sky130_fd_sc_hd__fill_1
XTAP_TAPCELL_ROW_75_1156 VGND VPWR sky130_fd_sc_hd__tapvpwrvgnd_1
XFILLER_111_529 VPWR VGND VPWR VGND sky130_ef_sc_hd__decap_12
XFILLER_104_581 VGND VGND VPWR VPWR sky130_fd_sc_hd__decap_6
XFILLER_89_281 VPWR VGND VPWR VGND sky130_ef_sc_hd__decap_12
XFILLER_65_605 VGND VGND VPWR VPWR sky130_fd_sc_hd__decap_4
XFILLER_37_329 VGND VGND VPWR VPWR sky130_fd_sc_hd__decap_6
XTAP_TAPCELL_ROW_48_825 VGND VPWR sky130_fd_sc_hd__tapvpwrvgnd_1
XPHY_EDGE_ROW_32_Left_149 VGND VGND VPWR VPWR sky130_fd_sc_hd__decap_3
XFILLER_73_660 VPWR VGND VPWR VGND sky130_ef_sc_hd__decap_12
XFILLER_33_513 VGND VGND VPWR VPWR sky130_fd_sc_hd__decap_3
XTAP_TAPCELL_ROW_86_1285 VGND VPWR sky130_fd_sc_hd__tapvpwrvgnd_1
XFILLER_72_170 VGND VGND VPWR VPWR sky130_fd_sc_hd__decap_4
XTAP_TAPCELL_ROW_28_582 VGND VPWR sky130_fd_sc_hd__tapvpwrvgnd_1
XTAP_TAPCELL_ROW_28_593 VGND VPWR sky130_fd_sc_hd__tapvpwrvgnd_1
X_3730_ net145 _2918_ _2929_ net137 VGND VGND VPWR VPWR _2930_ sky130_fd_sc_hd__a211o_1
XFILLER_13_281 VGND VGND VPWR VPWR sky130_fd_sc_hd__decap_8
X_3661_ _1332_ _1692_ net162 VGND VGND VPWR VPWR _2864_ sky130_fd_sc_hd__mux2_1
X_3592_ _2739_ _2794_ VGND VGND VPWR VPWR _2797_ sky130_fd_sc_hd__and2_1
X_5400_ _1191_ _1192_ _1077_ VGND VGND VPWR VPWR _1194_ sky130_fd_sc_hd__o21ba_1
XFILLER_62_3 VGND VGND VPWR VPWR sky130_fd_sc_hd__fill_2
X_6380_ _2066_ _2108_ _2261_ _2262_ VGND VGND VPWR VPWR _2263_ sky130_fd_sc_hd__a211oi_2
XPHY_EDGE_ROW_41_Left_158 VGND VGND VPWR VPWR sky130_fd_sc_hd__decap_3
X_5331_ _1047_ _1056_ _1055_ VGND VGND VPWR VPWR _1118_ sky130_fd_sc_hd__a21o_1
XFILLER_114_334 VGND VGND VPWR VPWR sky130_fd_sc_hd__decap_3
X_5262_ _1039_ _1042_ VGND VGND VPWR VPWR _1043_ sky130_fd_sc_hd__xnor2_1
XFILLER_102_529 VGND VGND VPWR VPWR sky130_fd_sc_hd__decap_3
X_5193_ _0956_ _0967_ VGND VGND VPWR VPWR _0968_ sky130_fd_sc_hd__nor2_1
XFILLER_68_421 VGND VGND VPWR VPWR sky130_fd_sc_hd__decap_8
X_4213_ _3390_ VGND VGND VPWR VPWR _3391_ sky130_fd_sc_hd__inv_2
X_4144_ _3325_ _3277_ net278 VGND VGND VPWR VPWR _3326_ sky130_fd_sc_hd__mux2_1
XFILLER_95_273 VGND VGND VPWR VPWR sky130_fd_sc_hd__fill_1
XFILLER_18_29 VPWR VGND VPWR VGND sky130_ef_sc_hd__decap_12
XPHY_EDGE_ROW_50_Left_167 VGND VGND VPWR VPWR sky130_fd_sc_hd__decap_3
X_4075_ net444 net447 net450 net461 net347 net279 VGND VGND VPWR VPWR _3260_ sky130_fd_sc_hd__mux4_1
XFILLER_55_137 VGND VGND VPWR VPWR sky130_fd_sc_hd__fill_1
XFILLER_24_524 VGND VGND VPWR VPWR sky130_fd_sc_hd__decap_3
X_4977_ net240 net227 net311 net260 VGND VGND VPWR VPWR _0735_ sky130_fd_sc_hd__nand4_1
X_6716_ _2618_ _2627_ VGND VGND VPWR VPWR _2629_ sky130_fd_sc_hd__xnor2_1
X_3928_ _3072_ _3094_ VGND VGND VPWR VPWR _3119_ sky130_fd_sc_hd__or2_1
X_3859_ _3027_ _3029_ _3024_ VGND VGND VPWR VPWR _3053_ sky130_fd_sc_hd__o21ba_1
X_6647_ _2551_ _2550_ VGND VGND VPWR VPWR _2554_ sky130_fd_sc_hd__nand2b_1
XFILLER_50_27 VGND VGND VPWR VPWR sky130_fd_sc_hd__fill_1
X_6578_ _2428_ _2429_ _2476_ _2477_ VGND VGND VPWR VPWR _2480_ sky130_fd_sc_hd__a22o_1
X_5529_ _1333_ _1334_ VGND VGND VPWR VPWR _1335_ sky130_fd_sc_hd__or2_1
Xfanout231 net233 VGND VGND VPWR VPWR net231 sky130_fd_sc_hd__buf_2
Xfanout220 net221 VGND VGND VPWR VPWR net220 sky130_fd_sc_hd__clkbuf_4
Xfanout242 net243 VGND VGND VPWR VPWR net242 sky130_fd_sc_hd__clkbuf_2
Xfanout264 net265 VGND VGND VPWR VPWR net264 sky130_fd_sc_hd__dlymetal6s2s_1
Xfanout253 net52 VGND VGND VPWR VPWR net253 sky130_fd_sc_hd__clkbuf_4
Xfanout286 net288 VGND VGND VPWR VPWR net286 sky130_fd_sc_hd__buf_2
XFILLER_101_573 VPWR VGND VPWR VGND sky130_ef_sc_hd__decap_12
XTAP_TAPCELL_ROW_70_1097 VGND VPWR sky130_fd_sc_hd__tapvpwrvgnd_1
XTAP_TAPCELL_ROW_70_1086 VGND VPWR sky130_fd_sc_hd__tapvpwrvgnd_1
Xfanout297 net298 VGND VGND VPWR VPWR net297 sky130_fd_sc_hd__clkbuf_2
Xfanout275 net276 VGND VGND VPWR VPWR net275 sky130_fd_sc_hd__buf_2
XFILLER_47_627 VPWR VGND VPWR VGND sky130_ef_sc_hd__decap_12
XFILLER_74_446 VPWR VGND VPWR VGND sky130_ef_sc_hd__decap_12
XFILLER_46_126 VPWR VGND VPWR VGND sky130_ef_sc_hd__decap_12
XFILLER_55_671 VGND VGND VPWR VPWR sky130_fd_sc_hd__fill_1
XFILLER_15_513 VGND VGND VPWR VPWR sky130_fd_sc_hd__fill_1
XFILLER_15_524 VPWR VGND VPWR VGND sky130_ef_sc_hd__decap_12
XFILLER_42_321 VPWR VGND VPWR VGND sky130_ef_sc_hd__decap_12
XFILLER_91_45 VGND VGND VPWR VPWR sky130_fd_sc_hd__decap_8
XTAP_TAPCELL_ROW_25_552 VGND VPWR sky130_fd_sc_hd__tapvpwrvgnd_1
XTAP_TAPCELL_ROW_53_883 VGND VPWR sky130_fd_sc_hd__tapvpwrvgnd_1
XFILLER_24_72 VGND VGND VPWR VPWR sky130_fd_sc_hd__decap_4
XFILLER_24_83 VGND VGND VPWR VPWR sky130_fd_sc_hd__fill_1
XFILLER_109_673 VPWR VGND VPWR VGND sky130_ef_sc_hd__decap_12
XFILLER_111_337 VGND VGND VPWR VPWR sky130_fd_sc_hd__decap_4
XFILLER_97_538 VGND VGND VPWR VPWR sky130_fd_sc_hd__decap_8
XTAP_TAPCELL_ROW_88_1303 VGND VPWR sky130_fd_sc_hd__tapvpwrvgnd_1
XFILLER_37_104 VGND VGND VPWR VPWR sky130_fd_sc_hd__decap_8
XFILLER_65_446 VGND VGND VPWR VPWR sky130_fd_sc_hd__fill_2
XFILLER_18_351 VPWR VGND VPWR VGND sky130_ef_sc_hd__decap_12
X_4900_ _0646_ _0657_ VGND VGND VPWR VPWR _0659_ sky130_fd_sc_hd__xnor2_1
X_5880_ _1716_ _1717_ VGND VGND VPWR VPWR _1718_ sky130_fd_sc_hd__nor2_1
X_4831_ _0588_ _0589_ _0579_ VGND VGND VPWR VPWR _0591_ sky130_fd_sc_hd__a21o_1
XFILLER_61_641 VPWR VGND VPWR VGND sky130_ef_sc_hd__decap_12
XFILLER_61_685 VGND VGND VPWR VPWR sky130_fd_sc_hd__decap_6
XFILLER_60_151 VGND VGND VPWR VPWR sky130_fd_sc_hd__decap_6
XFILLER_21_505 VGND VGND VPWR VPWR sky130_fd_sc_hd__decap_6
XFILLER_33_365 VPWR VGND VPWR VGND sky130_ef_sc_hd__decap_12
X_4762_ _0504_ _0521_ _0522_ VGND VGND VPWR VPWR _0523_ sky130_fd_sc_hd__nand3_1
X_4693_ _0383_ _0385_ _0453_ _0454_ VGND VGND VPWR VPWR _0455_ sky130_fd_sc_hd__a211oi_2
XTAP_TAPCELL_ROW_99_1443 VGND VPWR sky130_fd_sc_hd__tapvpwrvgnd_1
X_3713_ net244 _2673_ _2913_ net231 VGND VGND VPWR VPWR _2914_ sky130_fd_sc_hd__a211oi_2
X_6501_ _2393_ _2394_ VGND VGND VPWR VPWR _2395_ sky130_fd_sc_hd__xnor2_1
X_3644_ _2808_ _2814_ _2846_ VGND VGND VPWR VPWR _2847_ sky130_fd_sc_hd__a21o_1
X_6432_ _2318_ _2319_ VGND VGND VPWR VPWR _2320_ sky130_fd_sc_hd__and2_1
X_3575_ net423 net416 net408 net399 net355 net289 VGND VGND VPWR VPWR _2619_ sky130_fd_sc_hd__mux4_1
X_6363_ net258 net314 net305 net310 VGND VGND VPWR VPWR _2244_ sky130_fd_sc_hd__a22oi_1
XFILLER_115_665 VGND VGND VPWR VPWR sky130_fd_sc_hd__decap_6
X_5314_ net352 net462 _1011_ _1010_ VGND VGND VPWR VPWR _1099_ sky130_fd_sc_hd__a31o_1
X_6294_ _2005_ _2007_ _2166_ _2167_ VGND VGND VPWR VPWR _2169_ sky130_fd_sc_hd__a211o_1
X_5245_ _1014_ _1021_ _1022_ VGND VGND VPWR VPWR _1024_ sky130_fd_sc_hd__nand3_2
XFILLER_114_197 VGND VGND VPWR VPWR sky130_fd_sc_hd__decap_8
XFILLER_29_39 VPWR VGND VPWR VGND sky130_ef_sc_hd__decap_12
XFILLER_96_571 VPWR VGND VPWR VGND sky130_ef_sc_hd__decap_12
X_5176_ _0947_ _0948_ _0946_ VGND VGND VPWR VPWR _0949_ sky130_fd_sc_hd__a21o_1
X_4127_ _2958_ _3134_ _3309_ net122 VGND VGND VPWR VPWR _3310_ sky130_fd_sc_hd__a22o_1
XTAP_TAPCELL_ROW_108_1550 VGND VPWR sky130_fd_sc_hd__tapvpwrvgnd_1
X_4058_ net233 _3066_ _3242_ _1572_ VGND VGND VPWR VPWR _3244_ sky130_fd_sc_hd__a211o_1
XFILLER_43_107 VGND VGND VPWR VPWR sky130_fd_sc_hd__decap_4
XFILLER_45_38 VGND VGND VPWR VPWR sky130_fd_sc_hd__fill_2
XFILLER_37_671 VGND VGND VPWR VPWR sky130_fd_sc_hd__fill_1
XFILLER_52_641 VGND VGND VPWR VPWR sky130_fd_sc_hd__decap_3
XFILLER_24_321 VGND VGND VPWR VPWR sky130_fd_sc_hd__fill_1
XFILLER_101_55 VGND VGND VPWR VPWR sky130_fd_sc_hd__fill_1
XFILLER_24_365 VGND VGND VPWR VPWR sky130_fd_sc_hd__decap_6
XFILLER_51_162 VGND VGND VPWR VPWR sky130_fd_sc_hd__decap_6
XTAP_TAPCELL_ROW_22_511 VGND VPWR sky130_fd_sc_hd__tapvpwrvgnd_1
XTAP_TAPCELL_ROW_50_853 VGND VPWR sky130_fd_sc_hd__tapvpwrvgnd_1
XFILLER_106_643 VGND VGND VPWR VPWR sky130_fd_sc_hd__fill_1
XFILLER_3_225 VPWR VGND VPWR VGND sky130_ef_sc_hd__decap_12
XFILLER_3_203 VGND VGND VPWR VPWR sky130_fd_sc_hd__decap_6
XFILLER_79_505 VGND VGND VPWR VPWR sky130_fd_sc_hd__fill_2
XTAP_TAPCELL_ROW_72_1115 VGND VPWR sky130_fd_sc_hd__tapvpwrvgnd_1
XFILLER_10_41 VPWR VGND VPWR VGND sky130_ef_sc_hd__decap_12
XFILLER_59_240 VGND VGND VPWR VPWR sky130_fd_sc_hd__fill_1
XFILLER_74_221 VPWR VGND VPWR VGND sky130_ef_sc_hd__decap_12
XTAP_TAPCELL_ROW_58_942 VGND VPWR sky130_fd_sc_hd__tapvpwrvgnd_1
XTAP_TAPCELL_ROW_58_953 VGND VPWR sky130_fd_sc_hd__tapvpwrvgnd_1
XFILLER_62_438 VPWR VGND VPWR VGND sky130_ef_sc_hd__decap_12
XTAP_TAPCELL_ROW_2_280 VGND VPWR sky130_fd_sc_hd__tapvpwrvgnd_1
XPHY_EDGE_ROW_106_Left_223 VGND VGND VPWR VPWR sky130_fd_sc_hd__decap_3
XTAP_TAPCELL_ROW_83_1244 VGND VPWR sky130_fd_sc_hd__tapvpwrvgnd_1
XFILLER_43_641 VPWR VGND VPWR VGND sky130_ef_sc_hd__decap_12
XFILLER_70_471 VGND VGND VPWR VPWR sky130_fd_sc_hd__decap_4
XFILLER_43_685 VGND VGND VPWR VPWR sky130_fd_sc_hd__decap_6
XFILLER_42_195 VGND VGND VPWR VPWR sky130_fd_sc_hd__fill_1
XFILLER_116_429 VGND VGND VPWR VPWR sky130_fd_sc_hd__decap_3
XFILLER_7_553 VGND VGND VPWR VPWR sky130_fd_sc_hd__decap_6
XFILLER_51_92 VPWR VGND VPWR VGND sky130_ef_sc_hd__decap_12
XFILLER_109_481 VGND VGND VPWR VPWR sky130_fd_sc_hd__decap_3
XFILLER_7_597 VPWR VGND VPWR VGND sky130_ef_sc_hd__decap_12
XPHY_EDGE_ROW_115_Left_232 VGND VGND VPWR VPWR sky130_fd_sc_hd__decap_3
XTAP_TAPCELL_ROW_94_1384 VGND VPWR sky130_fd_sc_hd__tapvpwrvgnd_1
XFILLER_112_613 VPWR VGND VPWR VGND sky130_ef_sc_hd__decap_12
XFILLER_97_313 VGND VGND VPWR VPWR sky130_fd_sc_hd__decap_6
XFILLER_112_657 VPWR VGND VPWR VGND sky130_ef_sc_hd__decap_12
X_5030_ _0788_ _0790_ VGND VGND VPWR VPWR _0791_ sky130_fd_sc_hd__or2_1
XFILLER_25_3 VPWR VGND VPWR VGND sky130_ef_sc_hd__decap_12
XFILLER_93_541 VGND VGND VPWR VPWR sky130_fd_sc_hd__decap_6
XFILLER_53_405 VPWR VGND VPWR VGND sky130_ef_sc_hd__decap_12
X_5932_ net375 net302 _1600_ _1599_ VGND VGND VPWR VPWR _1774_ sky130_fd_sc_hd__a31o_1
XTAP_TAPCELL_ROW_0_239 VGND VPWR sky130_fd_sc_hd__tapvpwrvgnd_1
XFILLER_19_671 VGND VGND VPWR VPWR sky130_fd_sc_hd__fill_1
XFILLER_53_449 VGND VGND VPWR VPWR sky130_fd_sc_hd__decap_3
X_5863_ _1519_ _1521_ _1696_ _1697_ VGND VGND VPWR VPWR _1699_ sky130_fd_sc_hd__a211oi_2
X_4814_ _0562_ _0573_ VGND VGND VPWR VPWR _0574_ sky130_fd_sc_hd__nand2_1
XFILLER_61_493 VGND VGND VPWR VPWR sky130_fd_sc_hd__decap_8
X_5794_ net259 net337 _1620_ _1621_ VGND VGND VPWR VPWR _1623_ sky130_fd_sc_hd__a22o_1
X_4745_ _0439_ _0441_ VGND VGND VPWR VPWR _0506_ sky130_fd_sc_hd__nand2_1
XTAP_TAPCELL_ROW_103_1491 VGND VPWR sky130_fd_sc_hd__tapvpwrvgnd_1
X_4676_ net393 net210 net202 net401 VGND VGND VPWR VPWR _0438_ sky130_fd_sc_hd__a22o_1
XFILLER_107_429 VPWR VGND VPWR VGND sky130_ef_sc_hd__decap_12
X_3627_ net153 _2830_ VGND VGND VPWR VPWR _2831_ sky130_fd_sc_hd__nor2_1
X_6415_ _2298_ _2299_ _2142_ _2144_ VGND VGND VPWR VPWR _2301_ sky130_fd_sc_hd__a211o_1
X_3558_ net239 _2423_ VGND VGND VPWR VPWR _2434_ sky130_fd_sc_hd__or2_1
X_6346_ net464 net460 net185 net340 VGND VGND VPWR VPWR _2225_ sky130_fd_sc_hd__and4_1
XFILLER_115_473 VPWR VGND VPWR VGND sky130_ef_sc_hd__decap_12
XFILLER_102_134 VGND VGND VPWR VPWR sky130_fd_sc_hd__decap_6
X_3489_ net351 _0830_ _1670_ VGND VGND VPWR VPWR _1681_ sky130_fd_sc_hd__o21ai_1
X_6277_ _2146_ _2148_ _2127_ VGND VGND VPWR VPWR _2151_ sky130_fd_sc_hd__a21oi_1
XFILLER_76_519 VPWR VGND VPWR VGND sky130_ef_sc_hd__decap_12
X_5228_ _1002_ _1003_ _1005_ VGND VGND VPWR VPWR _1006_ sky130_fd_sc_hd__and3_1
X_5159_ _0824_ _0927_ _0929_ VGND VGND VPWR VPWR _0931_ sky130_fd_sc_hd__nor3_1
XFILLER_29_435 VGND VGND VPWR VPWR sky130_fd_sc_hd__decap_4
XFILLER_56_265 VGND VGND VPWR VPWR sky130_fd_sc_hd__decap_3
XFILLER_84_596 VPWR VGND VPWR VGND sky130_ef_sc_hd__decap_12
XFILLER_56_298 VGND VGND VPWR VPWR sky130_fd_sc_hd__fill_1
XTAP_TAPCELL_ROW_55_912 VGND VPWR sky130_fd_sc_hd__tapvpwrvgnd_1
XFILLER_16_129 VGND VGND VPWR VPWR sky130_fd_sc_hd__decap_8
XFILLER_112_65 VPWR VGND VPWR VGND sky130_ef_sc_hd__decap_12
XFILLER_25_641 VPWR VGND VPWR VGND sky130_ef_sc_hd__decap_12
XFILLER_72_58 VGND VGND VPWR VPWR sky130_fd_sc_hd__fill_1
XFILLER_71_279 VGND VGND VPWR VPWR sky130_fd_sc_hd__fill_1
XFILLER_25_685 VGND VGND VPWR VPWR sky130_fd_sc_hd__decap_6
XFILLER_4_501 VPWR VGND VPWR VGND sky130_ef_sc_hd__decap_12
XFILLER_21_51 VGND VGND VPWR VPWR sky130_fd_sc_hd__decap_4
XFILLER_4_545 VPWR VGND VPWR VGND sky130_ef_sc_hd__decap_12
XFILLER_97_55 VGND VGND VPWR VPWR sky130_fd_sc_hd__fill_1
XFILLER_79_324 VPWR VGND VPWR VGND sky130_ef_sc_hd__decap_12
XFILLER_4_589 VPWR VGND VPWR VGND sky130_ef_sc_hd__decap_12
XFILLER_94_338 VGND VGND VPWR VPWR sky130_fd_sc_hd__decap_4
XFILLER_47_232 VGND VGND VPWR VPWR sky130_fd_sc_hd__decap_4
XFILLER_90_533 VGND VGND VPWR VPWR sky130_fd_sc_hd__decap_8
XFILLER_90_511 VPWR VGND VPWR VGND sky130_ef_sc_hd__decap_12
XFILLER_75_585 VGND VGND VPWR VPWR sky130_fd_sc_hd__decap_4
XFILLER_62_235 VPWR VGND VPWR VGND sky130_ef_sc_hd__decap_12
XFILLER_35_449 VGND VGND VPWR VPWR sky130_fd_sc_hd__decap_6
XFILLER_43_471 VPWR VGND VPWR VGND sky130_ef_sc_hd__decap_12
X_4530_ _0290_ _0293_ VGND VGND VPWR VPWR _0294_ sky130_fd_sc_hd__xnor2_1
XTAP_TAPCELL_ROW_96_1402 VGND VPWR sky130_fd_sc_hd__tapvpwrvgnd_1
XFILLER_11_390 VGND VGND VPWR VPWR sky130_fd_sc_hd__fill_2
X_4461_ _0187_ _0224_ _0225_ VGND VGND VPWR VPWR _0227_ sky130_fd_sc_hd__or3_1
XFILLER_7_75 VGND VGND VPWR VPWR sky130_fd_sc_hd__fill_1
XFILLER_116_259 VGND VGND VPWR VPWR sky130_fd_sc_hd__decap_4
X_6200_ _1899_ _2063_ _2064_ VGND VGND VPWR VPWR _2066_ sky130_fd_sc_hd__nand3_1
X_3412_ net460 VGND VGND VPWR VPWR _0841_ sky130_fd_sc_hd__inv_2
X_4392_ _0157_ _0158_ VGND VGND VPWR VPWR _0159_ sky130_fd_sc_hd__nor2_1
X_6131_ _1987_ _1988_ _1967_ VGND VGND VPWR VPWR _1991_ sky130_fd_sc_hd__a21oi_1
XFILLER_112_421 VPWR VGND VPWR VGND sky130_ef_sc_hd__decap_12
XFILLER_97_121 VGND VGND VPWR VPWR sky130_fd_sc_hd__fill_1
XFILLER_97_110 VGND VGND VPWR VPWR sky130_fd_sc_hd__fill_2
XTAP_TAPCELL_ROW_5_309 VGND VPWR sky130_fd_sc_hd__tapvpwrvgnd_1
X_6062_ _1912_ _1913_ _1914_ VGND VGND VPWR VPWR _1915_ sky130_fd_sc_hd__and3_1
X_5013_ _0676_ _0679_ _0770_ _0771_ VGND VGND VPWR VPWR _0772_ sky130_fd_sc_hd__a211oi_4
XFILLER_78_390 VGND VGND VPWR VPWR sky130_fd_sc_hd__decap_6
XFILLER_66_541 VGND VGND VPWR VPWR sky130_fd_sc_hd__decap_3
XFILLER_26_29 VPWR VGND VPWR VGND sky130_ef_sc_hd__decap_12
XFILLER_38_265 VGND VGND VPWR VPWR sky130_fd_sc_hd__fill_2
XFILLER_93_393 VGND VGND VPWR VPWR sky130_fd_sc_hd__decap_3
XFILLER_81_555 VGND VGND VPWR VPWR sky130_fd_sc_hd__fill_1
XPHY_EDGE_ROW_5_Right_5 VGND VGND VPWR VPWR sky130_fd_sc_hd__decap_3
X_6895_ net183 _alu_i0.Datapath_i.fu_alu_33673_33851.out1\[21\] VGND VGND VPWR VPWR
+ _alu_i0.Datapath_i.reg_0.reg_out1\[21\] sky130_fd_sc_hd__dfxtp_1
X_5915_ _1752_ _1753_ _1734_ VGND VGND VPWR VPWR _1755_ sky130_fd_sc_hd__o21ai_1
XFILLER_41_408 VPWR VGND VPWR VGND sky130_ef_sc_hd__decap_12
X_5846_ net462 net212 VGND VGND VPWR VPWR _1680_ sky130_fd_sc_hd__nand2_1
XFILLER_21_143 VPWR VGND VPWR VGND sky130_ef_sc_hd__decap_12
XTAP_TAPCELL_ROW_60_970 VGND VPWR sky130_fd_sc_hd__tapvpwrvgnd_1
X_5777_ _1598_ _1603_ VGND VGND VPWR VPWR _1605_ sky130_fd_sc_hd__nand2_1
X_4728_ _0420_ _0428_ _0427_ VGND VGND VPWR VPWR _0489_ sky130_fd_sc_hd__o21ba_1
X_4659_ net251 net432 VGND VGND VPWR VPWR _0421_ sky130_fd_sc_hd__and2_1
XTAP_TAPCELL_ROW_116_1660 VGND VPWR sky130_fd_sc_hd__tapvpwrvgnd_1
XFILLER_107_259 VGND VGND VPWR VPWR sky130_fd_sc_hd__decap_3
XFILLER_115_281 VGND VGND VPWR VPWR sky130_fd_sc_hd__decap_3
XFILLER_88_132 VGND VGND VPWR VPWR sky130_fd_sc_hd__fill_2
X_6329_ net367 net274 VGND VGND VPWR VPWR _2207_ sky130_fd_sc_hd__nand2_1
XFILLER_1_559 VGND VGND VPWR VPWR sky130_fd_sc_hd__fill_1
XFILLER_88_176 VGND VGND VPWR VPWR sky130_fd_sc_hd__decap_6
XFILLER_103_498 VGND VGND VPWR VPWR sky130_fd_sc_hd__fill_1
XFILLER_57_530 VPWR VGND VPWR VGND sky130_ef_sc_hd__decap_12
XFILLER_29_221 VGND VGND VPWR VPWR sky130_fd_sc_hd__decap_3
XFILLER_91_319 VGND VGND VPWR VPWR sky130_fd_sc_hd__fill_1
XFILLER_57_585 VPWR VGND VPWR VGND sky130_ef_sc_hd__decap_12
XFILLER_83_57 VPWR VGND VPWR VGND sky130_ef_sc_hd__decap_12
XFILLER_72_533 VPWR VGND VPWR VGND sky130_ef_sc_hd__decap_12
XTAP_TAPCELL_ROW_67_1058 VGND VPWR sky130_fd_sc_hd__tapvpwrvgnd_1
XFILLER_17_449 VPWR VGND VPWR VGND sky130_ef_sc_hd__decap_12
XFILLER_29_298 VPWR VGND VPWR VGND sky130_ef_sc_hd__decap_12
XTAP_TAPCELL_ROW_80_1214 VGND VPWR sky130_fd_sc_hd__tapvpwrvgnd_1
XFILLER_9_615 VGND VGND VPWR VPWR sky130_fd_sc_hd__fill_1
XTAP_TAPCELL_ROW_30_609 VGND VPWR sky130_fd_sc_hd__tapvpwrvgnd_1
XFILLER_12_165 VGND VGND VPWR VPWR sky130_fd_sc_hd__decap_8
XFILLER_8_125 VGND VGND VPWR VPWR sky130_fd_sc_hd__fill_2
XFILLER_40_474 VGND VGND VPWR VPWR sky130_fd_sc_hd__fill_2
XTAP_TAPCELL_ROW_10_377 VGND VPWR sky130_fd_sc_hd__tapvpwrvgnd_1
XTAP_TAPCELL_ROW_10_366 VGND VPWR sky130_fd_sc_hd__tapvpwrvgnd_1
XTAP_TAPCELL_ROW_78_1187 VGND VPWR sky130_fd_sc_hd__tapvpwrvgnd_1
XFILLER_99_419 VPWR VGND VPWR VGND sky130_ef_sc_hd__decap_12
XTAP_TAPCELL_ROW_91_1343 VGND VPWR sky130_fd_sc_hd__tapvpwrvgnd_1
XTAP_TAPCELL_ROW_38_709 VGND VPWR sky130_fd_sc_hd__tapvpwrvgnd_1
XFILLER_57_91 VGND VGND VPWR VPWR sky130_fd_sc_hd__fill_2
XFILLER_75_393 VPWR VGND VPWR VGND sky130_ef_sc_hd__decap_12
X_3961_ _3144_ _3149_ _3129_ VGND VGND VPWR VPWR _3151_ sky130_fd_sc_hd__mux2_1
XTAP_TAPCELL_ROW_18_466 VGND VPWR sky130_fd_sc_hd__tapvpwrvgnd_1
XFILLER_35_279 VGND VGND VPWR VPWR sky130_fd_sc_hd__fill_1
XFILLER_50_205 VGND VGND VPWR VPWR sky130_fd_sc_hd__decap_6
XFILLER_16_482 VGND VGND VPWR VPWR sky130_fd_sc_hd__decap_8
X_5700_ _1425_ _1428_ _1518_ _1520_ VGND VGND VPWR VPWR _1521_ sky130_fd_sc_hd__a211o_1
XFILLER_50_216 VGND VGND VPWR VPWR sky130_fd_sc_hd__decap_6
XFILLER_50_238 VGND VGND VPWR VPWR sky130_fd_sc_hd__fill_2
XFILLER_92_3 VPWR VGND VPWR VGND sky130_ef_sc_hd__decap_12
X_3892_ net136 _3074_ _3079_ _3084_ net129 VGND VGND VPWR VPWR _3085_ sky130_fd_sc_hd__o221a_1
X_6680_ _2572_ _2587_ _2588_ VGND VGND VPWR VPWR _2590_ sky130_fd_sc_hd__nor3_1
XTAP_TAPCELL_ROW_100_1450 VGND VPWR sky130_fd_sc_hd__tapvpwrvgnd_1
X_5631_ _1320_ _1324_ _1444_ _1445_ VGND VGND VPWR VPWR _1446_ sky130_fd_sc_hd__o211a_1
XFILLER_31_474 VGND VGND VPWR VPWR sky130_fd_sc_hd__decap_3
X_5562_ _1366_ _1368_ _1239_ _1242_ VGND VGND VPWR VPWR _1370_ sky130_fd_sc_hd__o211ai_2
X_4513_ _0222_ _0276_ _0277_ VGND VGND VPWR VPWR _0278_ sky130_fd_sc_hd__and3_1
XFILLER_8_681 VGND VGND VPWR VPWR sky130_fd_sc_hd__decap_8
X_5493_ net388 net318 net307 net395 VGND VGND VPWR VPWR _1295_ sky130_fd_sc_hd__a22o_1
X_4444_ net287 net377 _0207_ _0208_ VGND VGND VPWR VPWR _0210_ sky130_fd_sc_hd__a22o_1
X_4375_ _1746_ _0107_ _0106_ VGND VGND VPWR VPWR _0143_ sky130_fd_sc_hd__a21o_1
XFILLER_112_240 VPWR VGND VPWR VGND sky130_ef_sc_hd__decap_12
XFILLER_58_305 VGND VGND VPWR VPWR sky130_fd_sc_hd__decap_3
X_6114_ _1971_ VGND VGND VPWR VPWR _1972_ sky130_fd_sc_hd__inv_2
XFILLER_86_625 VPWR VGND VPWR VGND sky130_ef_sc_hd__decap_12
XFILLER_85_102 VGND VGND VPWR VPWR sky130_fd_sc_hd__decap_8
X_6045_ _1877_ _1894_ _1895_ VGND VGND VPWR VPWR _1896_ sky130_fd_sc_hd__nand3_2
XFILLER_100_457 VPWR VGND VPWR VGND sky130_ef_sc_hd__decap_12
XFILLER_86_669 VPWR VGND VPWR VGND sky130_ef_sc_hd__decap_12
XFILLER_37_39 VPWR VGND VPWR VGND sky130_ef_sc_hd__decap_12
XFILLER_26_202 VGND VGND VPWR VPWR sky130_fd_sc_hd__decap_8
XFILLER_39_585 VPWR VGND VPWR VGND sky130_ef_sc_hd__decap_12
X_6878_ net180 _alu_i0.Datapath_i.fu_alu_33673_33851.out1\[4\] VGND VGND VPWR VPWR
+ _alu_i0.Datapath_i.reg_0.reg_out1\[4\] sky130_fd_sc_hd__dfxtp_1
XFILLER_41_249 VPWR VGND VPWR VGND sky130_ef_sc_hd__decap_12
XFILLER_10_625 VPWR VGND VPWR VGND sky130_ef_sc_hd__decap_12
X_5829_ net247 net443 VGND VGND VPWR VPWR _1662_ sky130_fd_sc_hd__nand2_1
XFILLER_10_669 VPWR VGND VPWR VGND sky130_ef_sc_hd__decap_12
XTAP_TAPCELL_ROW_114_1619 VGND VPWR sky130_fd_sc_hd__tapvpwrvgnd_1
XFILLER_108_557 VPWR VGND VPWR VGND sky130_ef_sc_hd__decap_12
XFILLER_49_305 VGND VGND VPWR VPWR sky130_fd_sc_hd__decap_4
XFILLER_103_262 VGND VGND VPWR VPWR sky130_fd_sc_hd__decap_4
XFILLER_49_349 VPWR VGND VPWR VGND sky130_ef_sc_hd__decap_12
XFILLER_94_89 VGND VGND VPWR VPWR sky130_fd_sc_hd__fill_1
XFILLER_85_691 VGND VGND VPWR VPWR sky130_fd_sc_hd__fill_1
XFILLER_72_330 VPWR VGND VPWR VGND sky130_ef_sc_hd__decap_12
XFILLER_57_393 VPWR VGND VPWR VGND sky130_ef_sc_hd__decap_12
XFILLER_45_522 VGND VGND VPWR VPWR sky130_fd_sc_hd__fill_1
XFILLER_60_503 VPWR VGND VPWR VGND sky130_ef_sc_hd__decap_12
XFILLER_17_257 VGND VGND VPWR VPWR sky130_fd_sc_hd__fill_2
XFILLER_17_279 VGND VGND VPWR VPWR sky130_fd_sc_hd__fill_1
XTAP_TAPCELL_ROW_15_436 VGND VPWR sky130_fd_sc_hd__tapvpwrvgnd_1
XFILLER_32_249 VGND VGND VPWR VPWR sky130_fd_sc_hd__decap_3
XTAP_TAPCELL_ROW_43_767 VGND VPWR sky130_fd_sc_hd__tapvpwrvgnd_1
XFILLER_40_260 VGND VGND VPWR VPWR sky130_fd_sc_hd__decap_4
XFILLER_40_282 VGND VGND VPWR VPWR sky130_fd_sc_hd__fill_1
XFILLER_5_673 VPWR VGND VPWR VGND sky130_ef_sc_hd__decap_12
XFILLER_99_249 VPWR VGND VPWR VGND sky130_ef_sc_hd__decap_12
XFILLER_4_65 VPWR VGND VPWR VGND sky130_ef_sc_hd__decap_12
X_4160_ net124 _3336_ _3337_ _3340_ VGND VGND VPWR VPWR _3341_ sky130_fd_sc_hd__a31o_1
XFILLER_67_113 VPWR VGND VPWR VGND sky130_ef_sc_hd__decap_12
XFILLER_4_98 VGND VGND VPWR VPWR sky130_fd_sc_hd__decap_8
XFILLER_95_466 VGND VGND VPWR VPWR sky130_fd_sc_hd__decap_3
XFILLER_68_669 VPWR VGND VPWR VGND sky130_ef_sc_hd__decap_12
X_4091_ net134 _3268_ _3274_ _3266_ net128 VGND VGND VPWR VPWR _3275_ sky130_fd_sc_hd__o221a_1
XFILLER_95_477 VGND VGND VPWR VPWR sky130_fd_sc_hd__decap_4
XFILLER_83_617 VPWR VGND VPWR VGND sky130_ef_sc_hd__decap_12
XFILLER_82_127 VPWR VGND VPWR VGND sky130_ef_sc_hd__decap_12
XFILLER_36_533 VPWR VGND VPWR VGND sky130_ef_sc_hd__decap_12
X_6801_ net470 net57 VGND VGND VPWR VPWR _2722_ sky130_fd_sc_hd__nand2_1
XFILLER_36_555 VPWR VGND VPWR VGND sky130_ef_sc_hd__decap_12
XFILLER_51_503 VGND VGND VPWR VPWR sky130_fd_sc_hd__fill_1
X_4993_ net365 net434 net210 net202 VGND VGND VPWR VPWR _0751_ sky130_fd_sc_hd__nand4_2
X_3944_ net222 _1539_ VGND VGND VPWR VPWR _3135_ sky130_fd_sc_hd__nand2_1
X_6732_ _2645_ _2646_ VGND VGND VPWR VPWR _2647_ sky130_fd_sc_hd__xnor2_1
XFILLER_51_558 VGND VGND VPWR VPWR sky130_fd_sc_hd__fill_2
X_3875_ _2882_ _2960_ VGND VGND VPWR VPWR _3069_ sky130_fd_sc_hd__nor2_1
X_6663_ _2561_ _2569_ VGND VGND VPWR VPWR _2571_ sky130_fd_sc_hd__nor2_1
XFILLER_31_293 VPWR VGND VPWR VGND sky130_ef_sc_hd__decap_12
X_5614_ _1425_ _1426_ _1412_ VGND VGND VPWR VPWR _1427_ sky130_fd_sc_hd__a21o_1
X_6594_ net413 net53 VGND VGND VPWR VPWR _2495_ sky130_fd_sc_hd__nand2_1
X_5545_ _2073_ _1350_ VGND VGND VPWR VPWR _1351_ sky130_fd_sc_hd__or2_1
X_5476_ _1274_ _1275_ VGND VGND VPWR VPWR _1276_ sky130_fd_sc_hd__nor2_1
X_4427_ net422 net214 _0155_ _0153_ VGND VGND VPWR VPWR _0193_ sky130_fd_sc_hd__a31o_1
Xfanout402 net28 VGND VGND VPWR VPWR net402 sky130_fd_sc_hd__buf_2
XFILLER_59_603 VPWR VGND VPWR VGND sky130_ef_sc_hd__decap_12
Xfanout413 net26 VGND VGND VPWR VPWR net413 sky130_fd_sc_hd__buf_2
Xfanout424 net425 VGND VGND VPWR VPWR net424 sky130_fd_sc_hd__clkbuf_4
X_4358_ _0123_ _0124_ _0122_ VGND VGND VPWR VPWR _0126_ sky130_fd_sc_hd__a21o_1
XFILLER_86_400 VGND VGND VPWR VPWR sky130_fd_sc_hd__decap_4
Xfanout457 net459 VGND VGND VPWR VPWR net457 sky130_fd_sc_hd__clkbuf_4
Xfanout446 net447 VGND VGND VPWR VPWR net446 sky130_fd_sc_hd__buf_2
XFILLER_48_27 VGND VGND VPWR VPWR sky130_fd_sc_hd__fill_1
Xfanout435 net19 VGND VGND VPWR VPWR net435 sky130_fd_sc_hd__buf_2
X_4289_ net286 net422 _0058_ VGND VGND VPWR VPWR _0060_ sky130_fd_sc_hd__and3_1
Xfanout468 net470 VGND VGND VPWR VPWR net468 sky130_fd_sc_hd__clkbuf_4
X_6028_ net374 net367 net297 net293 VGND VGND VPWR VPWR _1878_ sky130_fd_sc_hd__and4_1
XFILLER_46_319 VGND VGND VPWR VPWR sky130_fd_sc_hd__fill_1
XFILLER_104_77 VGND VGND VPWR VPWR sky130_fd_sc_hd__decap_6
XFILLER_67_691 VGND VGND VPWR VPWR sky130_fd_sc_hd__fill_1
XFILLER_64_48 VGND VGND VPWR VPWR sky130_fd_sc_hd__fill_1
XTAP_TAPCELL_ROW_64_1017 VGND VPWR sky130_fd_sc_hd__tapvpwrvgnd_1
XFILLER_42_558 VGND VGND VPWR VPWR sky130_fd_sc_hd__decap_6
XFILLER_10_411 VGND VGND VPWR VPWR sky130_fd_sc_hd__fill_2
XTAP_TAPCELL_ROW_40_726 VGND VPWR sky130_fd_sc_hd__tapvpwrvgnd_1
XTAP_TAPCELL_ROW_40_737 VGND VPWR sky130_fd_sc_hd__tapvpwrvgnd_1
XFILLER_6_415 VGND VGND VPWR VPWR sky130_fd_sc_hd__decap_4
XFILLER_6_404 VGND VGND VPWR VPWR sky130_fd_sc_hd__fill_1
XFILLER_89_23 VGND VGND VPWR VPWR sky130_fd_sc_hd__decap_6
XTAP_TAPCELL_ROW_20_494 VGND VPWR sky130_fd_sc_hd__tapvpwrvgnd_1
XFILLER_89_78 VPWR VGND VPWR VGND sky130_ef_sc_hd__decap_12
XTAP_TAPCELL_ROW_75_1157 VGND VPWR sky130_fd_sc_hd__tapvpwrvgnd_1
XTAP_TAPCELL_ROW_75_1146 VGND VPWR sky130_fd_sc_hd__tapvpwrvgnd_1
XFILLER_2_643 VGND VGND VPWR VPWR sky130_fd_sc_hd__fill_1
XFILLER_89_293 VPWR VGND VPWR VGND sky130_ef_sc_hd__decap_12
XFILLER_65_617 VPWR VGND VPWR VGND sky130_ef_sc_hd__decap_12
XTAP_TAPCELL_ROW_48_826 VGND VPWR sky130_fd_sc_hd__tapvpwrvgnd_1
XFILLER_57_190 VGND VGND VPWR VPWR sky130_fd_sc_hd__fill_2
XFILLER_33_503 VGND VGND VPWR VPWR sky130_fd_sc_hd__fill_1
XTAP_TAPCELL_ROW_86_1286 VGND VPWR sky130_fd_sc_hd__tapvpwrvgnd_1
XTAP_TAPCELL_ROW_28_583 VGND VPWR sky130_fd_sc_hd__tapvpwrvgnd_1
XFILLER_60_344 VGND VGND VPWR VPWR sky130_fd_sc_hd__fill_1
XFILLER_41_580 VGND VGND VPWR VPWR sky130_fd_sc_hd__decap_6
X_3660_ net246 _1593_ _2862_ net236 VGND VGND VPWR VPWR _2863_ sky130_fd_sc_hd__a211oi_1
X_3591_ _1092_ _1898_ _1855_ VGND VGND VPWR VPWR _2794_ sky130_fd_sc_hd__a21o_1
X_5330_ _2040_ _1115_ VGND VGND VPWR VPWR _1117_ sky130_fd_sc_hd__xnor2_1
XFILLER_55_3 VGND VGND VPWR VPWR sky130_fd_sc_hd__decap_4
X_5261_ _1040_ _1041_ VGND VGND VPWR VPWR _1042_ sky130_fd_sc_hd__and2b_1
X_4212_ net22 net54 VGND VGND VPWR VPWR _3390_ sky130_fd_sc_hd__nor2_1
X_5192_ _0818_ _0965_ VGND VGND VPWR VPWR _0967_ sky130_fd_sc_hd__xnor2_1
X_4143_ net347 _0874_ _2095_ VGND VGND VPWR VPWR _3325_ sky130_fd_sc_hd__o21ai_1
XFILLER_68_499 VPWR VGND VPWR VGND sky130_ef_sc_hd__decap_12
XFILLER_68_477 VGND VGND VPWR VPWR sky130_fd_sc_hd__decap_8
X_4074_ net132 _3247_ _3258_ _1539_ VGND VGND VPWR VPWR _3259_ sky130_fd_sc_hd__a211o_1
XFILLER_49_691 VGND VGND VPWR VPWR sky130_fd_sc_hd__fill_1
XFILLER_36_363 VGND VGND VPWR VPWR sky130_fd_sc_hd__fill_1
XFILLER_34_29 VPWR VGND VPWR VGND sky130_ef_sc_hd__decap_12
XFILLER_51_344 VPWR VGND VPWR VGND sky130_ef_sc_hd__decap_12
X_4976_ net240 net227 net311 net260 VGND VGND VPWR VPWR _0734_ sky130_fd_sc_hd__and4_1
X_6715_ _2618_ _2627_ VGND VGND VPWR VPWR _2628_ sky130_fd_sc_hd__and2b_1
X_3927_ _3027_ _3052_ _3075_ _3097_ VGND VGND VPWR VPWR _3118_ sky130_fd_sc_hd__or4_1
X_3858_ _3049_ _3050_ VGND VGND VPWR VPWR _3052_ sky130_fd_sc_hd__nand2_1
X_6646_ _2550_ _2551_ VGND VGND VPWR VPWR _2552_ sky130_fd_sc_hd__nand2b_1
X_3789_ _2964_ _2983_ _2984_ VGND VGND VPWR VPWR _2986_ sky130_fd_sc_hd__and3_1
X_6577_ _2428_ _2429_ _2476_ _2477_ VGND VGND VPWR VPWR _2479_ sky130_fd_sc_hd__nand4_1
X_5528_ _1206_ _1207_ _1208_ _1213_ VGND VGND VPWR VPWR _1334_ sky130_fd_sc_hd__o22a_1
XFILLER_105_357 VGND VGND VPWR VPWR sky130_fd_sc_hd__fill_2
X_5459_ _1254_ _1256_ _1136_ _1139_ VGND VGND VPWR VPWR _1258_ sky130_fd_sc_hd__o211a_1
Xfanout210 net61 VGND VGND VPWR VPWR net210 sky130_fd_sc_hd__clkbuf_4
Xfanout232 net233 VGND VGND VPWR VPWR net232 sky130_fd_sc_hd__buf_2
Xfanout221 net6 VGND VGND VPWR VPWR net221 sky130_fd_sc_hd__buf_4
XFILLER_101_530 VGND VGND VPWR VPWR sky130_fd_sc_hd__fill_1
Xfanout243 net58 VGND VGND VPWR VPWR net243 sky130_fd_sc_hd__clkbuf_4
Xfanout254 net51 VGND VGND VPWR VPWR net254 sky130_fd_sc_hd__clkbuf_4
Xfanout265 net49 VGND VGND VPWR VPWR net265 sky130_fd_sc_hd__buf_2
XFILLER_101_585 VPWR VGND VPWR VGND sky130_ef_sc_hd__decap_12
Xfanout287 net288 VGND VGND VPWR VPWR net287 sky130_fd_sc_hd__buf_1
XTAP_TAPCELL_ROW_70_1087 VGND VPWR sky130_fd_sc_hd__tapvpwrvgnd_1
Xfanout298 net42 VGND VGND VPWR VPWR net298 sky130_fd_sc_hd__clkbuf_2
Xfanout276 net45 VGND VGND VPWR VPWR net276 sky130_fd_sc_hd__clkbuf_4
XFILLER_47_639 VPWR VGND VPWR VGND sky130_ef_sc_hd__decap_12
XFILLER_74_458 VPWR VGND VPWR VGND sky130_ef_sc_hd__decap_12
XFILLER_46_138 VGND VGND VPWR VPWR sky130_fd_sc_hd__fill_2
XFILLER_62_609 VGND VGND VPWR VPWR sky130_fd_sc_hd__decap_3
XFILLER_15_503 VGND VGND VPWR VPWR sky130_fd_sc_hd__fill_1
XFILLER_15_536 VGND VGND VPWR VPWR sky130_fd_sc_hd__fill_2
XFILLER_91_57 VPWR VGND VPWR VGND sky130_ef_sc_hd__decap_12
XFILLER_54_193 VGND VGND VPWR VPWR sky130_fd_sc_hd__decap_3
XFILLER_15_558 VGND VGND VPWR VPWR sky130_fd_sc_hd__fill_2
XFILLER_42_333 VGND VGND VPWR VPWR sky130_fd_sc_hd__decap_6
XTAP_TAPCELL_ROW_25_553 VGND VPWR sky130_fd_sc_hd__tapvpwrvgnd_1
XTAP_TAPCELL_ROW_53_884 VGND VPWR sky130_fd_sc_hd__tapvpwrvgnd_1
XFILLER_109_641 VPWR VGND VPWR VGND sky130_ef_sc_hd__decap_12
XFILLER_10_274 VGND VGND VPWR VPWR sky130_fd_sc_hd__decap_4
XFILLER_109_685 VGND VGND VPWR VPWR sky130_fd_sc_hd__decap_6
XFILLER_40_72 VPWR VGND VPWR VGND sky130_ef_sc_hd__decap_12
XFILLER_108_184 VGND VGND VPWR VPWR sky130_fd_sc_hd__fill_2
XTAP_TAPCELL_ROW_88_1304 VGND VPWR sky130_fd_sc_hd__tapvpwrvgnd_1
XFILLER_77_285 VGND VGND VPWR VPWR sky130_fd_sc_hd__fill_1
XFILLER_1_55 VGND VGND VPWR VPWR sky130_fd_sc_hd__fill_1
XFILLER_18_341 VGND VGND VPWR VPWR sky130_fd_sc_hd__decap_3
XFILLER_18_363 VGND VGND VPWR VPWR sky130_fd_sc_hd__fill_1
XFILLER_33_300 VGND VGND VPWR VPWR sky130_fd_sc_hd__fill_1
X_4830_ _0579_ _0588_ _0589_ VGND VGND VPWR VPWR _0590_ sky130_fd_sc_hd__nand3_2
XFILLER_61_653 VPWR VGND VPWR VGND sky130_ef_sc_hd__decap_12
XFILLER_60_130 VGND VGND VPWR VPWR sky130_fd_sc_hd__fill_1
XFILLER_60_141 VGND VGND VPWR VPWR sky130_fd_sc_hd__decap_6
XFILLER_33_377 VPWR VGND VPWR VGND sky130_ef_sc_hd__decap_12
X_4761_ _0518_ _0519_ _0520_ VGND VGND VPWR VPWR _0522_ sky130_fd_sc_hd__a21o_1
X_4692_ _0451_ _0452_ _0434_ VGND VGND VPWR VPWR _0454_ sky130_fd_sc_hd__a21oi_1
XTAP_TAPCELL_ROW_99_1444 VGND VPWR sky130_fd_sc_hd__tapvpwrvgnd_1
X_3712_ net244 _2912_ VGND VGND VPWR VPWR _2913_ sky130_fd_sc_hd__nor2_1
X_6500_ net464 net336 VGND VGND VPWR VPWR _2394_ sky130_fd_sc_hd__nand2_1
X_3643_ net153 net416 VGND VGND VPWR VPWR _2846_ sky130_fd_sc_hd__and2_1
X_6431_ _2316_ _2317_ _2159_ _2162_ VGND VGND VPWR VPWR _2319_ sky130_fd_sc_hd__a211o_1
X_6362_ net310 net258 net314 net305 VGND VGND VPWR VPWR _2243_ sky130_fd_sc_hd__and4_1
X_5313_ _alu_i0.Datapath_i.reg_0.reg_out1\[19\] _1098_ net146 VGND VGND VPWR VPWR
+ net87 sky130_fd_sc_hd__mux2_1
X_3574_ net392 net378 net370 net362 net355 net289 VGND VGND VPWR VPWR _2608_ sky130_fd_sc_hd__mux4_1
XFILLER_114_121 VPWR VGND VPWR VGND sky130_ef_sc_hd__decap_12
XFILLER_88_517 VGND VGND VPWR VPWR sky130_fd_sc_hd__fill_1
X_6293_ _2166_ _2167_ _2005_ _2007_ VGND VGND VPWR VPWR _2168_ sky130_fd_sc_hd__o211ai_1
XFILLER_102_305 VGND VGND VPWR VPWR sky130_fd_sc_hd__decap_3
X_5244_ _1021_ _1022_ _1014_ VGND VGND VPWR VPWR _1023_ sky130_fd_sc_hd__a21o_1
X_5175_ net394 net332 net327 net402 VGND VGND VPWR VPWR _0948_ sky130_fd_sc_hd__a22o_1
XFILLER_96_583 VGND VGND VPWR VPWR sky130_fd_sc_hd__decap_4
XFILLER_68_241 VGND VGND VPWR VPWR sky130_fd_sc_hd__decap_8
X_4126_ _3041_ _3136_ _3219_ _3306_ net161 net157 VGND VGND VPWR VPWR _3309_ sky130_fd_sc_hd__mux4_1
XFILLER_29_617 VPWR VGND VPWR VGND sky130_ef_sc_hd__decap_12
XFILLER_68_296 VPWR VGND VPWR VGND sky130_ef_sc_hd__decap_12
XFILLER_56_436 VPWR VGND VPWR VGND sky130_ef_sc_hd__decap_12
X_4057_ _2889_ _3135_ VGND VGND VPWR VPWR _3243_ sky130_fd_sc_hd__or2_1
XFILLER_56_469 VGND VGND VPWR VPWR sky130_fd_sc_hd__decap_6
XFILLER_45_28 VGND VGND VPWR VPWR sky130_fd_sc_hd__fill_2
XTAP_TAPCELL_ROW_108_1551 VGND VPWR sky130_fd_sc_hd__tapvpwrvgnd_1
XFILLER_71_439 VGND VGND VPWR VPWR sky130_fd_sc_hd__decap_8
XFILLER_101_89 VGND VGND VPWR VPWR sky130_fd_sc_hd__fill_1
X_4959_ net417 net410 net334 net327 VGND VGND VPWR VPWR _0717_ sky130_fd_sc_hd__nand4_1
XTAP_TAPCELL_ROW_22_512 VGND VPWR sky130_fd_sc_hd__tapvpwrvgnd_1
XTAP_TAPCELL_ROW_50_854 VGND VPWR sky130_fd_sc_hd__tapvpwrvgnd_1
X_6629_ net367 net361 net273 net270 VGND VGND VPWR VPWR _2534_ sky130_fd_sc_hd__and4_1
XFILLER_105_143 VPWR VGND VPWR VGND sky130_ef_sc_hd__decap_12
XTAP_TAPCELL_ROW_72_1116 VGND VPWR sky130_fd_sc_hd__tapvpwrvgnd_1
XFILLER_10_53 VGND VGND VPWR VPWR sky130_fd_sc_hd__decap_3
XFILLER_3_237 VPWR VGND VPWR VGND sky130_ef_sc_hd__decap_12
XFILLER_79_528 VGND VGND VPWR VPWR sky130_fd_sc_hd__decap_4
XFILLER_86_35 VGND VGND VPWR VPWR sky130_fd_sc_hd__fill_1
XFILLER_87_561 VGND VGND VPWR VPWR sky130_fd_sc_hd__decap_6
XFILLER_101_393 VGND VGND VPWR VPWR sky130_fd_sc_hd__decap_8
XFILLER_101_371 VGND VGND VPWR VPWR sky130_fd_sc_hd__decap_8
XTAP_TAPCELL_ROW_58_943 VGND VPWR sky130_fd_sc_hd__tapvpwrvgnd_1
XFILLER_19_51 VGND VGND VPWR VPWR sky130_fd_sc_hd__decap_4
XFILLER_47_447 VGND VGND VPWR VPWR sky130_fd_sc_hd__fill_1
XFILLER_74_233 VGND VGND VPWR VPWR sky130_fd_sc_hd__decap_8
XFILLER_62_417 VGND VGND VPWR VPWR sky130_fd_sc_hd__decap_3
XTAP_TAPCELL_ROW_2_270 VGND VPWR sky130_fd_sc_hd__tapvpwrvgnd_1
XTAP_TAPCELL_ROW_2_281 VGND VPWR sky130_fd_sc_hd__tapvpwrvgnd_1
XTAP_TAPCELL_ROW_83_1245 VGND VPWR sky130_fd_sc_hd__tapvpwrvgnd_1
XFILLER_43_653 VPWR VGND VPWR VGND sky130_ef_sc_hd__decap_12
XFILLER_30_303 VGND VGND VPWR VPWR sky130_fd_sc_hd__fill_2
XFILLER_89_9 VGND VGND VPWR VPWR sky130_fd_sc_hd__decap_8
XFILLER_11_561 VPWR VGND VPWR VGND sky130_ef_sc_hd__decap_12
XTAP_TAPCELL_ROW_94_1374 VGND VPWR sky130_fd_sc_hd__tapvpwrvgnd_1
XFILLER_112_625 VPWR VGND VPWR VGND sky130_ef_sc_hd__decap_12
XFILLER_97_325 VGND VGND VPWR VPWR sky130_fd_sc_hd__decap_8
XTAP_TAPCELL_ROW_94_1385 VGND VPWR sky130_fd_sc_hd__tapvpwrvgnd_1
XFILLER_112_669 VPWR VGND VPWR VGND sky130_ef_sc_hd__decap_12
XFILLER_111_113 VGND VGND VPWR VPWR sky130_fd_sc_hd__decap_3
XFILLER_65_200 VGND VGND VPWR VPWR sky130_fd_sc_hd__decap_3
XFILLER_18_3 VPWR VGND VPWR VGND sky130_ef_sc_hd__decap_12
XFILLER_93_553 VGND VGND VPWR VPWR sky130_fd_sc_hd__decap_6
XFILLER_53_417 VGND VGND VPWR VPWR sky130_fd_sc_hd__decap_8
X_5931_ _1632_ _1635_ VGND VGND VPWR VPWR _1773_ sky130_fd_sc_hd__nand2_1
XFILLER_80_247 VGND VGND VPWR VPWR sky130_fd_sc_hd__fill_1
XFILLER_61_472 VGND VGND VPWR VPWR sky130_fd_sc_hd__decap_8
X_5862_ _1674_ _1694_ _1695_ VGND VGND VPWR VPWR _1698_ sky130_fd_sc_hd__nand3_2
X_4813_ _0563_ _0572_ VGND VGND VPWR VPWR _0573_ sky130_fd_sc_hd__xnor2_1
X_5793_ net259 net337 _1620_ _1621_ VGND VGND VPWR VPWR _1622_ sky130_fd_sc_hd__nand4_1
XFILLER_33_185 VGND VGND VPWR VPWR sky130_fd_sc_hd__fill_1
X_4744_ _0442_ _0445_ VGND VGND VPWR VPWR _0505_ sky130_fd_sc_hd__nand2_1
XTAP_TAPCELL_ROW_103_1492 VGND VPWR sky130_fd_sc_hd__tapvpwrvgnd_1
X_4675_ net417 net194 _0345_ _0344_ VGND VGND VPWR VPWR _0437_ sky130_fd_sc_hd__a31o_1
X_3626_ _2828_ _2829_ net250 VGND VGND VPWR VPWR _2830_ sky130_fd_sc_hd__mux2_1
X_6414_ _2142_ _2144_ _2298_ _2299_ VGND VGND VPWR VPWR _2300_ sky130_fd_sc_hd__o211ai_4
XFILLER_115_441 VGND VGND VPWR VPWR sky130_fd_sc_hd__decap_6
X_3557_ _2379_ _2412_ net158 VGND VGND VPWR VPWR _2423_ sky130_fd_sc_hd__mux2_1
X_6345_ net460 net185 net340 net464 VGND VGND VPWR VPWR _2224_ sky130_fd_sc_hd__a22oi_1
XFILLER_115_485 VPWR VGND VPWR VGND sky130_ef_sc_hd__decap_12
X_6276_ _2127_ _2146_ _2148_ VGND VGND VPWR VPWR _2149_ sky130_fd_sc_hd__and3_1
XFILLER_102_124 VGND VGND VPWR VPWR sky130_fd_sc_hd__decap_3
X_3488_ net356 net176 VGND VGND VPWR VPWR _1670_ sky130_fd_sc_hd__nand2_1
X_5227_ _0892_ _0894_ _0893_ VGND VGND VPWR VPWR _1005_ sky130_fd_sc_hd__a21bo_1
XFILLER_69_561 VPWR VGND VPWR VGND sky130_ef_sc_hd__decap_12
XFILLER_111_691 VGND VGND VPWR VPWR sky130_fd_sc_hd__fill_1
XFILLER_84_531 VGND VGND VPWR VPWR sky130_fd_sc_hd__fill_1
X_5158_ _0929_ VGND VGND VPWR VPWR _0930_ sky130_fd_sc_hd__inv_2
XFILLER_69_594 VGND VGND VPWR VPWR sky130_fd_sc_hd__fill_2
XFILLER_56_27 VGND VGND VPWR VPWR sky130_fd_sc_hd__fill_1
X_5089_ net313 net215 _0851_ _0853_ VGND VGND VPWR VPWR _0855_ sky130_fd_sc_hd__nand4_2
XFILLER_29_447 VGND VGND VPWR VPWR sky130_fd_sc_hd__fill_1
XFILLER_29_469 VPWR VGND VPWR VGND sky130_ef_sc_hd__decap_12
X_4109_ _3285_ _3290_ net125 VGND VGND VPWR VPWR _3292_ sky130_fd_sc_hd__o21a_1
XTAP_TAPCELL_ROW_55_913 VGND VPWR sky130_fd_sc_hd__tapvpwrvgnd_1
XFILLER_112_77 VGND VGND VPWR VPWR sky130_fd_sc_hd__decap_6
XFILLER_72_15 VPWR VGND VPWR VGND sky130_ef_sc_hd__decap_12
XFILLER_71_225 VPWR VGND VPWR VGND sky130_ef_sc_hd__decap_12
XFILLER_25_653 VPWR VGND VPWR VGND sky130_ef_sc_hd__decap_12
XTAP_TAPCELL_ROW_35_670 VGND VPWR sky130_fd_sc_hd__tapvpwrvgnd_1
XFILLER_40_645 VPWR VGND VPWR VGND sky130_ef_sc_hd__decap_12
XFILLER_12_347 VGND VGND VPWR VPWR sky130_fd_sc_hd__fill_1
XFILLER_40_689 VGND VGND VPWR VPWR sky130_fd_sc_hd__decap_3
XFILLER_4_513 VPWR VGND VPWR VGND sky130_ef_sc_hd__decap_12
XFILLER_106_452 VGND VGND VPWR VPWR sky130_fd_sc_hd__decap_8
XFILLER_106_441 VGND VGND VPWR VPWR sky130_fd_sc_hd__fill_1
XFILLER_4_557 VPWR VGND VPWR VGND sky130_ef_sc_hd__decap_12
XTAP_TAPCELL_ROW_7_340 VGND VPWR sky130_fd_sc_hd__tapvpwrvgnd_1
XFILLER_67_509 VGND VGND VPWR VPWR sky130_fd_sc_hd__fill_1
XFILLER_87_391 VGND VGND VPWR VPWR sky130_fd_sc_hd__fill_1
XFILLER_47_200 VGND VGND VPWR VPWR sky130_fd_sc_hd__decap_6
XFILLER_47_211 VGND VGND VPWR VPWR sky130_fd_sc_hd__decap_4
XFILLER_47_244 VPWR VGND VPWR VGND sky130_ef_sc_hd__decap_12
XFILLER_90_523 VGND VGND VPWR VPWR sky130_fd_sc_hd__fill_1
XFILLER_62_247 VGND VGND VPWR VPWR sky130_fd_sc_hd__decap_4
XFILLER_46_82 VGND VGND VPWR VPWR sky130_fd_sc_hd__fill_2
XFILLER_90_589 VPWR VGND VPWR VGND sky130_ef_sc_hd__decap_12
XFILLER_90_567 VGND VGND VPWR VPWR sky130_fd_sc_hd__fill_1
XFILLER_62_269 VGND VGND VPWR VPWR sky130_fd_sc_hd__decap_6
XFILLER_43_461 VGND VGND VPWR VPWR sky130_fd_sc_hd__decap_6
XFILLER_50_409 VGND VGND VPWR VPWR sky130_fd_sc_hd__fill_2
XFILLER_43_483 VPWR VGND VPWR VGND sky130_ef_sc_hd__decap_12
XFILLER_62_81 VGND VGND VPWR VPWR sky130_fd_sc_hd__decap_3
XFILLER_30_177 VGND VGND VPWR VPWR sky130_fd_sc_hd__fill_1
XTAP_TAPCELL_ROW_96_1403 VGND VPWR sky130_fd_sc_hd__tapvpwrvgnd_1
X_4460_ _0187_ _0224_ _0225_ VGND VGND VPWR VPWR _0226_ sky130_fd_sc_hd__nor3_1
XFILLER_116_238 VPWR VGND VPWR VGND sky130_ef_sc_hd__decap_12
X_4391_ _0120_ _0156_ VGND VGND VPWR VPWR _0158_ sky130_fd_sc_hd__nor2_1
X_3411_ net220 VGND VGND VPWR VPWR _0830_ sky130_fd_sc_hd__inv_2
XFILLER_98_601 VPWR VGND VPWR VGND sky130_ef_sc_hd__decap_12
X_6130_ _1967_ _1987_ _1988_ VGND VGND VPWR VPWR _1990_ sky130_fd_sc_hd__nand3_1
XFILLER_112_433 VPWR VGND VPWR VGND sky130_ef_sc_hd__decap_12
XFILLER_98_645 VPWR VGND VPWR VGND sky130_ef_sc_hd__decap_12
XFILLER_112_477 VPWR VGND VPWR VGND sky130_ef_sc_hd__decap_12
XFILLER_98_689 VGND VGND VPWR VPWR sky130_fd_sc_hd__decap_3
X_6061_ _1764_ _1766_ VGND VGND VPWR VPWR _1914_ sky130_fd_sc_hd__nand2_1
XFILLER_97_177 VGND VGND VPWR VPWR sky130_fd_sc_hd__fill_2
X_5012_ _0768_ _0769_ _0643_ VGND VGND VPWR VPWR _0771_ sky130_fd_sc_hd__o21a_1
XFILLER_93_361 VPWR VGND VPWR VGND sky130_ef_sc_hd__decap_12
XFILLER_81_523 VGND VGND VPWR VPWR sky130_fd_sc_hd__fill_1
XFILLER_66_586 VGND VGND VPWR VPWR sky130_fd_sc_hd__fill_2
XTAP_TAPCELL_ROW_105_1510 VGND VPWR sky130_fd_sc_hd__tapvpwrvgnd_1
XFILLER_53_225 VGND VGND VPWR VPWR sky130_fd_sc_hd__decap_6
XFILLER_53_247 VGND VGND VPWR VPWR sky130_fd_sc_hd__decap_3
X_6894_ net183 _alu_i0.Datapath_i.fu_alu_33673_33851.out1\[20\] VGND VGND VPWR VPWR
+ _alu_i0.Datapath_i.reg_0.reg_out1\[20\] sky130_fd_sc_hd__dfxtp_1
X_5914_ _1734_ _1752_ _1753_ VGND VGND VPWR VPWR _1754_ sky130_fd_sc_hd__or3_2
XFILLER_22_601 VPWR VGND VPWR VGND sky130_ef_sc_hd__decap_12
XFILLER_21_111 VGND VGND VPWR VPWR sky130_fd_sc_hd__fill_1
X_5845_ net466 net206 net199 net168 VGND VGND VPWR VPWR _1679_ sky130_fd_sc_hd__a22o_1
XFILLER_22_645 VPWR VGND VPWR VGND sky130_ef_sc_hd__decap_12
XTAP_TAPCELL_ROW_32_640 VGND VPWR sky130_fd_sc_hd__tapvpwrvgnd_1
XFILLER_42_29 VPWR VGND VPWR VGND sky130_ef_sc_hd__decap_12
XTAP_TAPCELL_ROW_60_971 VGND VPWR sky130_fd_sc_hd__tapvpwrvgnd_1
X_5776_ _1601_ _1602_ VGND VGND VPWR VPWR _1603_ sky130_fd_sc_hd__xnor2_1
XFILLER_21_155 VPWR VGND VPWR VGND sky130_ef_sc_hd__decap_12
XFILLER_22_689 VGND VGND VPWR VPWR sky130_fd_sc_hd__decap_3
X_4727_ _0479_ _0487_ VGND VGND VPWR VPWR _0488_ sky130_fd_sc_hd__xor2_1
XFILLER_107_205 VPWR VGND VPWR VGND sky130_ef_sc_hd__decap_12
X_4658_ net289 net386 VGND VGND VPWR VPWR _0420_ sky130_fd_sc_hd__nand2_1
XTAP_TAPCELL_ROW_116_1661 VGND VPWR sky130_fd_sc_hd__tapvpwrvgnd_1
XTAP_TAPCELL_ROW_116_1650 VGND VPWR sky130_fd_sc_hd__tapvpwrvgnd_1
X_3609_ net158 net423 VGND VGND VPWR VPWR _2813_ sky130_fd_sc_hd__nand2_1
XFILLER_115_260 VGND VGND VPWR VPWR sky130_fd_sc_hd__fill_1
X_4589_ _0263_ _0320_ VGND VGND VPWR VPWR _0352_ sky130_fd_sc_hd__nor2_1
XFILLER_1_505 VPWR VGND VPWR VGND sky130_ef_sc_hd__decap_12
XFILLER_107_55 VGND VGND VPWR VPWR sky130_fd_sc_hd__fill_1
X_6328_ _2203_ _2205_ VGND VGND VPWR VPWR _2206_ sky130_fd_sc_hd__nor2_1
XFILLER_103_477 VGND VGND VPWR VPWR sky130_fd_sc_hd__fill_1
XFILLER_67_15 VPWR VGND VPWR VGND sky130_ef_sc_hd__decap_12
X_6259_ net465 net193 _1904_ _1903_ VGND VGND VPWR VPWR _2131_ sky130_fd_sc_hd__a31o_1
XFILLER_69_391 VGND VGND VPWR VPWR sky130_fd_sc_hd__fill_1
XFILLER_57_542 VGND VGND VPWR VPWR sky130_fd_sc_hd__decap_4
XFILLER_57_597 VPWR VGND VPWR VGND sky130_ef_sc_hd__decap_12
XFILLER_29_288 VGND VGND VPWR VPWR sky130_fd_sc_hd__decap_3
XFILLER_84_383 VGND VGND VPWR VPWR sky130_fd_sc_hd__fill_1
XFILLER_83_69 VGND VGND VPWR VPWR sky130_fd_sc_hd__decap_6
XFILLER_44_225 VGND VGND VPWR VPWR sky130_fd_sc_hd__fill_2
XFILLER_72_589 VPWR VGND VPWR VGND sky130_ef_sc_hd__decap_12
XTAP_TAPCELL_ROW_67_1059 VGND VPWR sky130_fd_sc_hd__tapvpwrvgnd_1
XFILLER_16_41 VPWR VGND VPWR VGND sky130_ef_sc_hd__decap_12
XTAP_TAPCELL_ROW_80_1215 VGND VPWR sky130_fd_sc_hd__tapvpwrvgnd_1
XPHY_EDGE_ROW_11_Right_11 VGND VGND VPWR VPWR sky130_fd_sc_hd__decap_3
XFILLER_12_133 VGND VGND VPWR VPWR sky130_fd_sc_hd__decap_6
XFILLER_40_497 VGND VGND VPWR VPWR sky130_fd_sc_hd__decap_8
XTAP_TAPCELL_ROW_10_367 VGND VPWR sky130_fd_sc_hd__tapvpwrvgnd_1
XTAP_TAPCELL_ROW_78_1188 VGND VPWR sky130_fd_sc_hd__tapvpwrvgnd_1
XTAP_TAPCELL_ROW_91_1344 VGND VPWR sky130_fd_sc_hd__tapvpwrvgnd_1
XPHY_EDGE_ROW_20_Right_20 VGND VGND VPWR VPWR sky130_fd_sc_hd__decap_3
XFILLER_95_615 VGND VGND VPWR VPWR sky130_fd_sc_hd__fill_1
XFILLER_79_166 VGND VGND VPWR VPWR sky130_fd_sc_hd__fill_2
XFILLER_94_125 VPWR VGND VPWR VGND sky130_ef_sc_hd__decap_12
XFILLER_48_531 VGND VGND VPWR VPWR sky130_fd_sc_hd__fill_1
XFILLER_35_225 VGND VGND VPWR VPWR sky130_fd_sc_hd__fill_1
XFILLER_90_353 VGND VGND VPWR VPWR sky130_fd_sc_hd__fill_2
X_3960_ net170 _0961_ _3144_ VGND VGND VPWR VPWR _3150_ sky130_fd_sc_hd__and3_1
XTAP_TAPCELL_ROW_18_467 VGND VPWR sky130_fd_sc_hd__tapvpwrvgnd_1
XTAP_TAPCELL_ROW_46_798 VGND VPWR sky130_fd_sc_hd__tapvpwrvgnd_1
X_3891_ _3083_ net123 _3082_ VGND VGND VPWR VPWR _3084_ sky130_fd_sc_hd__and3b_1
XTAP_TAPCELL_ROW_100_1451 VGND VPWR sky130_fd_sc_hd__tapvpwrvgnd_1
XFILLER_85_3 VPWR VGND VPWR VGND sky130_ef_sc_hd__decap_12
X_5630_ _1442_ _1443_ _1254_ _1257_ VGND VGND VPWR VPWR _1445_ sky130_fd_sc_hd__a211o_1
X_5561_ _1239_ _1242_ _1366_ _1368_ VGND VGND VPWR VPWR _1369_ sky130_fd_sc_hd__a211o_2
X_4512_ _0217_ _0273_ VGND VGND VPWR VPWR _0277_ sky130_fd_sc_hd__or2_1
X_5492_ net412 net303 _1147_ _1145_ VGND VGND VPWR VPWR _1294_ sky130_fd_sc_hd__a31o_1
XFILLER_7_181 VPWR VGND VPWR VGND sky130_ef_sc_hd__decap_12
X_4443_ net286 net377 _0207_ _0208_ VGND VGND VPWR VPWR _0209_ sky130_fd_sc_hd__nand4_1
X_4374_ _0109_ _0140_ VGND VGND VPWR VPWR _0142_ sky130_fd_sc_hd__xnor2_1
X_6113_ net462 net449 net205 net198 VGND VGND VPWR VPWR _1971_ sky130_fd_sc_hd__and4_1
XTAP_TAPCELL_ROW_111_1580 VGND VPWR sky130_fd_sc_hd__tapvpwrvgnd_1
XFILLER_86_637 VGND VGND VPWR VPWR sky130_fd_sc_hd__decap_6
X_6044_ _1892_ _1893_ _1732_ VGND VGND VPWR VPWR _1895_ sky130_fd_sc_hd__a21o_1
XFILLER_100_469 VGND VGND VPWR VPWR sky130_fd_sc_hd__decap_6
XFILLER_85_136 VPWR VGND VPWR VGND sky130_ef_sc_hd__decap_12
XFILLER_39_553 VGND VGND VPWR VPWR sky130_fd_sc_hd__decap_6
XFILLER_94_681 VGND VGND VPWR VPWR sky130_fd_sc_hd__decap_8
XFILLER_85_169 VGND VGND VPWR VPWR sky130_fd_sc_hd__decap_3
XFILLER_39_597 VPWR VGND VPWR VGND sky130_ef_sc_hd__decap_12
XFILLER_54_589 VGND VGND VPWR VPWR sky130_fd_sc_hd__decap_4
X_6877_ net180 _alu_i0.Datapath_i.fu_alu_33673_33851.out1\[3\] VGND VGND VPWR VPWR
+ _alu_i0.Datapath_i.reg_0.reg_out1\[3\] sky130_fd_sc_hd__dfxtp_1
X_5828_ _1658_ _1660_ VGND VGND VPWR VPWR _1661_ sky130_fd_sc_hd__and2b_1
X_5759_ _alu_i0.Datapath_i.reg_0.reg_out1\[23\] _1585_ net147 VGND VGND VPWR VPWR
+ net92 sky130_fd_sc_hd__mux2_1
XFILLER_10_637 VGND VGND VPWR VPWR sky130_fd_sc_hd__decap_6
XFILLER_108_569 VPWR VGND VPWR VGND sky130_ef_sc_hd__decap_12
XFILLER_77_604 VPWR VGND VPWR VGND sky130_ef_sc_hd__decap_12
XFILLER_57_350 VPWR VGND VPWR VGND sky130_ef_sc_hd__decap_12
XFILLER_45_501 VGND VGND VPWR VPWR sky130_fd_sc_hd__decap_3
XFILLER_17_225 VGND VGND VPWR VPWR sky130_fd_sc_hd__decap_4
XFILLER_17_236 VPWR VGND VPWR VGND sky130_ef_sc_hd__decap_12
XFILLER_27_51 VGND VGND VPWR VPWR sky130_fd_sc_hd__decap_4
XFILLER_72_342 VPWR VGND VPWR VGND sky130_ef_sc_hd__decap_12
XFILLER_60_537 VGND VGND VPWR VPWR sky130_fd_sc_hd__fill_1
XFILLER_60_515 VGND VGND VPWR VPWR sky130_fd_sc_hd__decap_8
XTAP_TAPCELL_ROW_15_426 VGND VPWR sky130_fd_sc_hd__tapvpwrvgnd_1
XTAP_TAPCELL_ROW_15_437 VGND VPWR sky130_fd_sc_hd__tapvpwrvgnd_1
XTAP_TAPCELL_ROW_43_768 VGND VPWR sky130_fd_sc_hd__tapvpwrvgnd_1
XFILLER_43_83 VPWR VGND VPWR VGND sky130_ef_sc_hd__decap_12
XFILLER_64_8 VGND VGND VPWR VPWR sky130_fd_sc_hd__fill_2
XFILLER_5_641 VPWR VGND VPWR VGND sky130_ef_sc_hd__decap_12
XFILLER_99_206 VGND VGND VPWR VPWR sky130_fd_sc_hd__decap_4
XFILLER_5_685 VGND VGND VPWR VPWR sky130_fd_sc_hd__decap_6
XFILLER_4_195 VGND VGND VPWR VPWR sky130_fd_sc_hd__fill_1
XFILLER_4_77 VGND VGND VPWR VPWR sky130_fd_sc_hd__decap_6
XFILLER_95_434 VGND VGND VPWR VPWR sky130_fd_sc_hd__decap_3
XFILLER_67_125 VGND VGND VPWR VPWR sky130_fd_sc_hd__decap_8
XFILLER_0_390 VGND VGND VPWR VPWR sky130_fd_sc_hd__fill_2
X_4090_ _3271_ _3273_ _3269_ VGND VGND VPWR VPWR _3274_ sky130_fd_sc_hd__mux2_1
XFILLER_83_629 VPWR VGND VPWR VGND sky130_ef_sc_hd__decap_12
XFILLER_67_169 VGND VGND VPWR VPWR sky130_fd_sc_hd__decap_3
XFILLER_48_361 VGND VGND VPWR VPWR sky130_fd_sc_hd__decap_3
XFILLER_82_139 VGND VGND VPWR VPWR sky130_fd_sc_hd__fill_1
XFILLER_76_681 VGND VGND VPWR VPWR sky130_fd_sc_hd__decap_8
XFILLER_36_545 VGND VGND VPWR VPWR sky130_fd_sc_hd__decap_4
XFILLER_48_383 VPWR VGND VPWR VGND sky130_ef_sc_hd__decap_12
XFILLER_91_673 VPWR VGND VPWR VGND sky130_ef_sc_hd__decap_12
X_6800_ net359 net430 net271 net268 VGND VGND VPWR VPWR _2721_ sky130_fd_sc_hd__nand4_1
XFILLER_36_567 VPWR VGND VPWR VGND sky130_ef_sc_hd__decap_12
X_4992_ net380 net194 _0627_ _0626_ VGND VGND VPWR VPWR _0750_ sky130_fd_sc_hd__a31o_1
XFILLER_90_161 VPWR VGND VPWR VGND sky130_ef_sc_hd__decap_12
XFILLER_23_206 VPWR VGND VPWR VGND sky130_ef_sc_hd__decap_12
X_3943_ _0808_ _1550_ VGND VGND VPWR VPWR _3134_ sky130_fd_sc_hd__nor2_4
X_6731_ _2428_ _2479_ VGND VGND VPWR VPWR _2646_ sky130_fd_sc_hd__nand2_1
X_3874_ net152 _2888_ _3067_ VGND VGND VPWR VPWR _3068_ sky130_fd_sc_hd__o21ai_1
X_6662_ _2561_ _2569_ VGND VGND VPWR VPWR _2570_ sky130_fd_sc_hd__and2_1
X_5613_ _1422_ _1423_ _1424_ VGND VGND VPWR VPWR _1426_ sky130_fd_sc_hd__a21o_1
X_6593_ net413 net253 net53 net419 VGND VGND VPWR VPWR _2494_ sky130_fd_sc_hd__a22oi_1
X_5544_ _1347_ _1348_ VGND VGND VPWR VPWR _1350_ sky130_fd_sc_hd__xor2_1
X_5475_ net384 net309 net186 net341 VGND VGND VPWR VPWR _1275_ sky130_fd_sc_hd__and4_1
X_4426_ _0190_ _0191_ VGND VGND VPWR VPWR _0192_ sky130_fd_sc_hd__xnor2_2
Xfanout414 net418 VGND VGND VPWR VPWR net414 sky130_fd_sc_hd__buf_2
Xfanout403 net404 VGND VGND VPWR VPWR net403 sky130_fd_sc_hd__buf_2
XFILLER_113_561 VPWR VGND VPWR VGND sky130_ef_sc_hd__decap_12
X_4357_ _0122_ _0123_ _0124_ VGND VGND VPWR VPWR _0125_ sky130_fd_sc_hd__nand3_1
Xfanout425 net426 VGND VGND VPWR VPWR net425 sky130_fd_sc_hd__clkbuf_4
XFILLER_59_615 VGND VGND VPWR VPWR sky130_fd_sc_hd__fill_1
Xfanout447 net14 VGND VGND VPWR VPWR net447 sky130_fd_sc_hd__clkbuf_2
Xfanout436 net437 VGND VGND VPWR VPWR net436 sky130_fd_sc_hd__buf_2
Xfanout458 net459 VGND VGND VPWR VPWR net458 sky130_fd_sc_hd__clkbuf_2
X_4288_ net286 net422 VGND VGND VPWR VPWR _0059_ sky130_fd_sc_hd__nand2_1
XFILLER_86_434 VGND VGND VPWR VPWR sky130_fd_sc_hd__fill_1
Xfanout469 net470 VGND VGND VPWR VPWR net469 sky130_fd_sc_hd__clkbuf_4
XFILLER_67_670 VGND VGND VPWR VPWR sky130_fd_sc_hd__fill_2
X_6027_ _1744_ _1750_ _1742_ VGND VGND VPWR VPWR _1877_ sky130_fd_sc_hd__a21o_1
XFILLER_27_501 VGND VGND VPWR VPWR sky130_fd_sc_hd__decap_3
XFILLER_66_180 VPWR VGND VPWR VGND sky130_ef_sc_hd__decap_12
XFILLER_64_27 VGND VGND VPWR VPWR sky130_fd_sc_hd__fill_1
XFILLER_27_512 VPWR VGND VPWR VGND sky130_ef_sc_hd__decap_12
XTAP_TAPCELL_ROW_64_1018 VGND VPWR sky130_fd_sc_hd__tapvpwrvgnd_1
XFILLER_80_15 VPWR VGND VPWR VGND sky130_ef_sc_hd__decap_12
XTAP_TAPCELL_ROW_40_727 VGND VPWR sky130_fd_sc_hd__tapvpwrvgnd_1
XFILLER_108_300 VGND VGND VPWR VPWR sky130_fd_sc_hd__fill_1
XFILLER_10_445 VGND VGND VPWR VPWR sky130_fd_sc_hd__fill_2
XFILLER_89_46 VGND VGND VPWR VPWR sky130_fd_sc_hd__fill_1
XTAP_TAPCELL_ROW_20_495 VGND VPWR sky130_fd_sc_hd__tapvpwrvgnd_1
XFILLER_108_399 VGND VGND VPWR VPWR sky130_fd_sc_hd__decap_3
XTAP_TAPCELL_ROW_75_1147 VGND VPWR sky130_fd_sc_hd__tapvpwrvgnd_1
XFILLER_77_401 VGND VGND VPWR VPWR sky130_fd_sc_hd__decap_3
XFILLER_1_165 VGND VGND VPWR VPWR sky130_fd_sc_hd__decap_3
XFILLER_65_629 VPWR VGND VPWR VGND sky130_ef_sc_hd__decap_12
XFILLER_38_72 VGND VGND VPWR VPWR sky130_fd_sc_hd__decap_4
XTAP_TAPCELL_ROW_48_827 VGND VPWR sky130_fd_sc_hd__tapvpwrvgnd_1
XFILLER_49_169 VGND VGND VPWR VPWR sky130_fd_sc_hd__decap_8
XFILLER_58_681 VGND VGND VPWR VPWR sky130_fd_sc_hd__decap_8
XFILLER_18_556 VPWR VGND VPWR VGND sky130_ef_sc_hd__decap_12
XTAP_TAPCELL_ROW_86_1287 VGND VPWR sky130_fd_sc_hd__tapvpwrvgnd_1
XFILLER_73_673 VPWR VGND VPWR VGND sky130_ef_sc_hd__decap_12
XFILLER_18_589 VPWR VGND VPWR VGND sky130_ef_sc_hd__decap_12
XTAP_TAPCELL_ROW_28_584 VGND VPWR sky130_fd_sc_hd__tapvpwrvgnd_1
XFILLER_45_386 VGND VGND VPWR VPWR sky130_fd_sc_hd__decap_6
XFILLER_72_183 VPWR VGND VPWR VGND sky130_ef_sc_hd__decap_12
XFILLER_33_548 VGND VGND VPWR VPWR sky130_fd_sc_hd__decap_4
XFILLER_20_209 VPWR VGND VPWR VGND sky130_ef_sc_hd__decap_12
X_3590_ _1070_ _2728_ _2772_ VGND VGND VPWR VPWR _2783_ sky130_fd_sc_hd__o21bai_1
XFILLER_114_314 VGND VGND VPWR VPWR sky130_fd_sc_hd__decap_3
X_5260_ net459 net300 net295 net469 VGND VGND VPWR VPWR _1041_ sky130_fd_sc_hd__a22o_1
XFILLER_87_209 VGND VGND VPWR VPWR sky130_fd_sc_hd__fill_1
X_4211_ _3384_ _3389_ VGND VGND VPWR VPWR _alu_i0.Datapath_i.fu_alu_33673_33851.out1\[28\]
+ sky130_fd_sc_hd__or2_1
X_5191_ _0818_ _0965_ VGND VGND VPWR VPWR _0966_ sky130_fd_sc_hd__and2_1
XFILLER_110_531 VGND VGND VPWR VPWR sky130_fd_sc_hd__fill_1
X_4142_ net131 _3314_ _3319_ _3323_ VGND VGND VPWR VPWR _3324_ sky130_fd_sc_hd__a22o_1
XFILLER_56_607 VPWR VGND VPWR VGND sky130_ef_sc_hd__decap_12
X_4073_ _3252_ _3256_ _3257_ VGND VGND VPWR VPWR _3258_ sky130_fd_sc_hd__a21oi_1
XFILLER_55_117 VGND VGND VPWR VPWR sky130_fd_sc_hd__fill_1
XFILLER_36_331 VGND VGND VPWR VPWR sky130_fd_sc_hd__decap_4
XFILLER_36_342 VGND VGND VPWR VPWR sky130_fd_sc_hd__decap_8
XFILLER_24_537 VGND VGND VPWR VPWR sky130_fd_sc_hd__decap_6
X_4975_ net290 net177 VGND VGND VPWR VPWR _0733_ sky130_fd_sc_hd__nand2_1
XFILLER_51_356 VPWR VGND VPWR VGND sky130_ef_sc_hd__decap_12
X_3926_ _3075_ _3097_ _3116_ VGND VGND VPWR VPWR _3117_ sky130_fd_sc_hd__or3_1
X_6714_ _2620_ _2626_ VGND VGND VPWR VPWR _2627_ sky130_fd_sc_hd__xor2_1
X_3857_ _3049_ _3050_ VGND VGND VPWR VPWR _3051_ sky130_fd_sc_hd__and2_1
X_6645_ _2194_ _2356_ _2380_ VGND VGND VPWR VPWR _2551_ sky130_fd_sc_hd__a21bo_1
X_3788_ _2964_ _2984_ _2983_ VGND VGND VPWR VPWR _2985_ sky130_fd_sc_hd__a21oi_1
X_6576_ _2474_ _2475_ _2300_ _2302_ VGND VGND VPWR VPWR _2477_ sky130_fd_sc_hd__o211ai_1
X_5527_ _1330_ _1331_ VGND VGND VPWR VPWR _1333_ sky130_fd_sc_hd__nand2b_1
XFILLER_3_419 VPWR VGND VPWR VGND sky130_ef_sc_hd__decap_12
XFILLER_105_369 VGND VGND VPWR VPWR sky130_fd_sc_hd__decap_4
XFILLER_78_209 VGND VGND VPWR VPWR sky130_fd_sc_hd__decap_4
X_5458_ _1136_ _1139_ _1254_ _1256_ VGND VGND VPWR VPWR _1257_ sky130_fd_sc_hd__a211oi_2
X_4409_ _0137_ _0174_ VGND VGND VPWR VPWR _0176_ sky130_fd_sc_hd__xnor2_1
Xfanout211 net61 VGND VGND VPWR VPWR net211 sky130_fd_sc_hd__clkbuf_2
Xfanout222 net230 VGND VGND VPWR VPWR net222 sky130_fd_sc_hd__clkbuf_4
Xfanout200 net62 VGND VGND VPWR VPWR net200 sky130_fd_sc_hd__clkbuf_4
X_5389_ _1171_ _1181_ VGND VGND VPWR VPWR _1182_ sky130_fd_sc_hd__xor2_1
XFILLER_115_55 VGND VGND VPWR VPWR sky130_fd_sc_hd__fill_1
Xfanout244 net245 VGND VGND VPWR VPWR net244 sky130_fd_sc_hd__clkbuf_4
Xfanout233 net243 VGND VGND VPWR VPWR net233 sky130_fd_sc_hd__clkbuf_2
Xfanout255 net51 VGND VGND VPWR VPWR net255 sky130_fd_sc_hd__clkbuf_2
Xfanout288 net44 VGND VGND VPWR VPWR net288 sky130_fd_sc_hd__clkbuf_2
XFILLER_75_15 VPWR VGND VPWR VGND sky130_ef_sc_hd__decap_12
XTAP_TAPCELL_ROW_70_1088 VGND VPWR sky130_fd_sc_hd__tapvpwrvgnd_1
Xfanout277 net281 VGND VGND VPWR VPWR net277 sky130_fd_sc_hd__clkbuf_4
Xfanout299 net42 VGND VGND VPWR VPWR net299 sky130_fd_sc_hd__clkbuf_4
Xfanout266 net267 VGND VGND VPWR VPWR net266 sky130_fd_sc_hd__buf_2
XFILLER_101_597 VPWR VGND VPWR VGND sky130_ef_sc_hd__decap_12
XFILLER_86_297 VGND VGND VPWR VPWR sky130_fd_sc_hd__decap_8
XFILLER_55_673 VPWR VGND VPWR VGND sky130_ef_sc_hd__decap_12
XFILLER_70_643 VGND VGND VPWR VPWR sky130_fd_sc_hd__fill_1
XFILLER_91_69 VGND VGND VPWR VPWR sky130_fd_sc_hd__decap_6
XFILLER_24_41 VPWR VGND VPWR VGND sky130_ef_sc_hd__decap_12
XTAP_TAPCELL_ROW_25_554 VGND VPWR sky130_fd_sc_hd__tapvpwrvgnd_1
XTAP_TAPCELL_ROW_53_885 VGND VPWR sky130_fd_sc_hd__tapvpwrvgnd_1
XFILLER_24_63 VGND VGND VPWR VPWR sky130_fd_sc_hd__decap_6
XFILLER_24_85 VPWR VGND VPWR VGND sky130_ef_sc_hd__decap_12
XFILLER_10_286 VPWR VGND VPWR VGND sky130_ef_sc_hd__decap_12
XFILLER_10_264 VGND VGND VPWR VPWR sky130_fd_sc_hd__decap_3
XFILLER_109_653 VPWR VGND VPWR VGND sky130_ef_sc_hd__decap_12
XFILLER_40_95 VPWR VGND VPWR VGND sky130_ef_sc_hd__decap_12
XFILLER_111_317 VGND VGND VPWR VPWR sky130_fd_sc_hd__decap_8
XFILLER_2_474 VGND VGND VPWR VPWR sky130_fd_sc_hd__fill_2
XFILLER_49_82 VGND VGND VPWR VPWR sky130_fd_sc_hd__decap_3
XTAP_TAPCELL_ROW_88_1305 VGND VPWR sky130_fd_sc_hd__tapvpwrvgnd_1
XFILLER_92_223 VPWR VGND VPWR VGND sky130_ef_sc_hd__decap_12
XFILLER_61_665 VGND VGND VPWR VPWR sky130_fd_sc_hd__decap_6
X_4760_ _0518_ _0519_ _0520_ VGND VGND VPWR VPWR _0521_ sky130_fd_sc_hd__nand3_1
XFILLER_60_197 VGND VGND VPWR VPWR sky130_fd_sc_hd__fill_1
XFILLER_14_581 VGND VGND VPWR VPWR sky130_fd_sc_hd__decap_6
XFILLER_33_389 VGND VGND VPWR VPWR sky130_fd_sc_hd__decap_3
XPHY_EDGE_ROW_112_Right_112 VGND VGND VPWR VPWR sky130_fd_sc_hd__decap_3
X_4691_ _0434_ _0451_ _0452_ VGND VGND VPWR VPWR _0453_ sky130_fd_sc_hd__and3_1
XTAP_TAPCELL_ROW_99_1445 VGND VPWR sky130_fd_sc_hd__tapvpwrvgnd_1
XTAP_TAPCELL_ROW_99_1434 VGND VPWR sky130_fd_sc_hd__tapvpwrvgnd_1
X_3711_ net392 net400 net408 net416 net349 net280 VGND VGND VPWR VPWR _2912_ sky130_fd_sc_hd__mux4_1
X_3642_ _2842_ _2843_ VGND VGND VPWR VPWR _2845_ sky130_fd_sc_hd__or2_1
X_6430_ _2159_ _2162_ _2316_ _2317_ VGND VGND VPWR VPWR _2318_ sky130_fd_sc_hd__o211ai_2
X_6361_ _2089_ _2091_ VGND VGND VPWR VPWR _2242_ sky130_fd_sc_hd__nand2_1
X_5312_ _1096_ _1097_ VGND VGND VPWR VPWR _1098_ sky130_fd_sc_hd__xnor2_1
X_3573_ _2575_ _2586_ net251 VGND VGND VPWR VPWR _2597_ sky130_fd_sc_hd__mux2_1
XPHY_EDGE_ROW_49_Right_49 VGND VGND VPWR VPWR sky130_fd_sc_hd__decap_3
XFILLER_114_133 VGND VGND VPWR VPWR sky130_fd_sc_hd__fill_1
X_6292_ _2164_ _2165_ _1962_ _1966_ VGND VGND VPWR VPWR _2167_ sky130_fd_sc_hd__o211a_1
XFILLER_114_177 VPWR VGND VPWR VGND sky130_ef_sc_hd__decap_12
X_5243_ _1019_ _1020_ _1016_ VGND VGND VPWR VPWR _1022_ sky130_fd_sc_hd__a21o_1
X_5174_ net402 net394 net334 net327 VGND VGND VPWR VPWR _0947_ sky130_fd_sc_hd__nand4_1
XFILLER_68_253 VGND VGND VPWR VPWR sky130_fd_sc_hd__fill_1
X_4125_ net151 net117 VGND VGND VPWR VPWR _3308_ sky130_fd_sc_hd__nand2_1
XFILLER_56_404 VGND VGND VPWR VPWR sky130_fd_sc_hd__fill_1
XFILLER_29_629 VPWR VGND VPWR VGND sky130_ef_sc_hd__decap_12
XFILLER_83_223 VGND VGND VPWR VPWR sky130_fd_sc_hd__fill_1
XFILLER_56_448 VGND VGND VPWR VPWR sky130_fd_sc_hd__fill_2
XFILLER_28_139 VGND VGND VPWR VPWR sky130_fd_sc_hd__fill_1
X_4056_ net154 _3241_ VGND VGND VPWR VPWR _3242_ sky130_fd_sc_hd__and2_1
XPHY_EDGE_ROW_58_Right_58 VGND VGND VPWR VPWR sky130_fd_sc_hd__decap_3
XTAP_TAPCELL_ROW_108_1552 VGND VPWR sky130_fd_sc_hd__tapvpwrvgnd_1
XFILLER_37_673 VPWR VGND VPWR VGND sky130_ef_sc_hd__decap_12
XFILLER_101_57 VPWR VGND VPWR VGND sky130_ef_sc_hd__decap_12
XFILLER_51_153 VGND VGND VPWR VPWR sky130_fd_sc_hd__fill_2
X_4958_ net402 net338 VGND VGND VPWR VPWR _0716_ sky130_fd_sc_hd__and2_1
XTAP_TAPCELL_ROW_22_513 VGND VPWR sky130_fd_sc_hd__tapvpwrvgnd_1
X_4889_ net251 net260 VGND VGND VPWR VPWR _0648_ sky130_fd_sc_hd__and2_1
X_3909_ _3099_ _3100_ _3097_ VGND VGND VPWR VPWR _3101_ sky130_fd_sc_hd__mux2_1
XTAP_TAPCELL_ROW_50_855 VGND VPWR sky130_fd_sc_hd__tapvpwrvgnd_1
X_6628_ net359 net273 net270 net367 VGND VGND VPWR VPWR _2533_ sky130_fd_sc_hd__a22oi_1
XFILLER_106_601 VPWR VGND VPWR VGND sky130_ef_sc_hd__decap_12
XPHY_EDGE_ROW_67_Right_67 VGND VGND VPWR VPWR sky130_fd_sc_hd__decap_3
X_6559_ _2451_ _2457_ VGND VGND VPWR VPWR _2459_ sky130_fd_sc_hd__xnor2_1
XFILLER_106_645 VPWR VGND VPWR VGND sky130_ef_sc_hd__decap_12
XFILLER_3_249 VPWR VGND VPWR VGND sky130_ef_sc_hd__decap_12
XFILLER_106_689 VGND VGND VPWR VPWR sky130_fd_sc_hd__decap_3
XFILLER_105_155 VPWR VGND VPWR VGND sky130_ef_sc_hd__decap_12
XTAP_TAPCELL_ROW_72_1117 VGND VPWR sky130_fd_sc_hd__tapvpwrvgnd_1
XFILLER_87_595 VPWR VGND VPWR VGND sky130_ef_sc_hd__decap_12
XPHY_EDGE_ROW_76_Right_76 VGND VGND VPWR VPWR sky130_fd_sc_hd__decap_3
XFILLER_74_212 VGND VGND VPWR VPWR sky130_fd_sc_hd__fill_2
XFILLER_19_128 VPWR VGND VPWR VGND sky130_ef_sc_hd__decap_12
XTAP_TAPCELL_ROW_58_944 VGND VPWR sky130_fd_sc_hd__tapvpwrvgnd_1
XTAP_TAPCELL_ROW_2_271 VGND VPWR sky130_fd_sc_hd__tapvpwrvgnd_1
XFILLER_43_610 VGND VGND VPWR VPWR sky130_fd_sc_hd__decap_6
XFILLER_35_51 VGND VGND VPWR VPWR sky130_fd_sc_hd__decap_4
XTAP_TAPCELL_ROW_83_1246 VGND VPWR sky130_fd_sc_hd__tapvpwrvgnd_1
XFILLER_43_665 VGND VGND VPWR VPWR sky130_fd_sc_hd__decap_6
XFILLER_30_337 VPWR VGND VPWR VGND sky130_ef_sc_hd__decap_12
XFILLER_35_95 VGND VGND VPWR VPWR sky130_fd_sc_hd__decap_4
XFILLER_42_197 VGND VGND VPWR VPWR sky130_fd_sc_hd__decap_3
XPHY_EDGE_ROW_85_Right_85 VGND VGND VPWR VPWR sky130_fd_sc_hd__decap_3
XFILLER_11_573 VPWR VGND VPWR VGND sky130_ef_sc_hd__decap_12
XFILLER_51_61 VPWR VGND VPWR VGND sky130_ef_sc_hd__decap_12
XFILLER_109_461 VPWR VGND VPWR VGND sky130_ef_sc_hd__decap_12
XTAP_TAPCELL_ROW_94_1375 VGND VPWR sky130_fd_sc_hd__tapvpwrvgnd_1
XFILLER_112_637 VGND VGND VPWR VPWR sky130_fd_sc_hd__decap_6
XFILLER_97_348 VPWR VGND VPWR VGND sky130_ef_sc_hd__decap_12
XFILLER_97_337 VGND VGND VPWR VPWR sky130_fd_sc_hd__decap_4
XPHY_EDGE_ROW_29_Left_146 VGND VGND VPWR VPWR sky130_fd_sc_hd__decap_3
XFILLER_111_169 VGND VGND VPWR VPWR sky130_fd_sc_hd__fill_1
XPHY_EDGE_ROW_94_Right_94 VGND VGND VPWR VPWR sky130_fd_sc_hd__decap_3
XFILLER_19_673 VPWR VGND VPWR VGND sky130_ef_sc_hd__decap_12
X_5930_ _1763_ _1771_ VGND VGND VPWR VPWR _1772_ sky130_fd_sc_hd__xnor2_1
XFILLER_34_643 VGND VGND VPWR VPWR sky130_fd_sc_hd__fill_1
XFILLER_46_481 VPWR VGND VPWR VGND sky130_ef_sc_hd__decap_12
X_5861_ _1674_ _1694_ _1695_ VGND VGND VPWR VPWR _1697_ sky130_fd_sc_hd__and3_1
X_4812_ _0570_ _0571_ VGND VGND VPWR VPWR _0572_ sky130_fd_sc_hd__nor2_1
XFILLER_21_337 VGND VGND VPWR VPWR sky130_fd_sc_hd__decap_6
X_5792_ net383 net309 net331 net325 VGND VGND VPWR VPWR _1621_ sky130_fd_sc_hd__nand4_1
XPHY_EDGE_ROW_38_Left_155 VGND VGND VPWR VPWR sky130_fd_sc_hd__decap_3
XTAP_TAPCELL_ROW_103_1493 VGND VPWR sky130_fd_sc_hd__tapvpwrvgnd_1
XTAP_TAPCELL_ROW_103_1482 VGND VPWR sky130_fd_sc_hd__tapvpwrvgnd_1
X_4743_ _1648_ _0502_ VGND VGND VPWR VPWR _0504_ sky130_fd_sc_hd__xnor2_1
X_4674_ _0373_ _0376_ VGND VGND VPWR VPWR _0436_ sky130_fd_sc_hd__nand2_1
X_6413_ _2295_ _2297_ _2137_ _2140_ VGND VGND VPWR VPWR _2299_ sky130_fd_sc_hd__o211ai_2
X_3625_ _2346_ _2029_ net284 VGND VGND VPWR VPWR _2829_ sky130_fd_sc_hd__mux2_1
X_3556_ net456 net423 net416 net408 net354 net284 VGND VGND VPWR VPWR _2412_ sky130_fd_sc_hd__mux4_1
X_6344_ _2220_ _2221_ _2034_ _2063_ VGND VGND VPWR VPWR _2223_ sky130_fd_sc_hd__o211a_1
XFILLER_103_615 VGND VGND VPWR VPWR sky130_fd_sc_hd__fill_1
XFILLER_0_219 VGND VGND VPWR VPWR sky130_fd_sc_hd__decap_4
X_6275_ _2144_ _2145_ _1982_ _1984_ VGND VGND VPWR VPWR _2148_ sky130_fd_sc_hd__o211ai_1
XPHY_EDGE_ROW_47_Left_164 VGND VGND VPWR VPWR sky130_fd_sc_hd__decap_3
XFILLER_115_497 VGND VGND VPWR VPWR sky130_fd_sc_hd__decap_6
XFILLER_88_326 VGND VGND VPWR VPWR sky130_fd_sc_hd__fill_1
X_3487_ net165 net311 _1648_ VGND VGND VPWR VPWR _1659_ sky130_fd_sc_hd__a21bo_1
X_5226_ net246 net167 _1000_ _1001_ VGND VGND VPWR VPWR _1003_ sky130_fd_sc_hd__nand4_1
XFILLER_69_540 VPWR VGND VPWR VGND sky130_ef_sc_hd__decap_12
X_5157_ _0907_ _0925_ _0926_ VGND VGND VPWR VPWR _0929_ sky130_fd_sc_hd__and3_1
XFILLER_69_573 VGND VGND VPWR VPWR sky130_fd_sc_hd__fill_2
XFILLER_96_392 VGND VGND VPWR VPWR sky130_fd_sc_hd__decap_3
X_5088_ net313 net215 _0851_ _0853_ VGND VGND VPWR VPWR _0854_ sky130_fd_sc_hd__a22o_1
X_4108_ _3285_ _3290_ VGND VGND VPWR VPWR _3291_ sky130_fd_sc_hd__nand2_1
XTAP_TAPCELL_ROW_55_914 VGND VPWR sky130_fd_sc_hd__tapvpwrvgnd_1
XFILLER_37_470 VPWR VGND VPWR VGND sky130_ef_sc_hd__decap_12
X_4039_ _3224_ VGND VGND VPWR VPWR _3225_ sky130_fd_sc_hd__inv_2
XFILLER_44_418 VGND VGND VPWR VPWR sky130_fd_sc_hd__fill_2
XFILLER_71_237 VPWR VGND VPWR VGND sky130_ef_sc_hd__decap_12
XFILLER_72_27 VGND VGND VPWR VPWR sky130_fd_sc_hd__fill_1
XPHY_EDGE_ROW_56_Left_173 VGND VGND VPWR VPWR sky130_fd_sc_hd__decap_3
XFILLER_52_451 VPWR VGND VPWR VGND sky130_ef_sc_hd__decap_12
XFILLER_25_665 VGND VGND VPWR VPWR sky130_fd_sc_hd__decap_6
XFILLER_12_304 VGND VGND VPWR VPWR sky130_fd_sc_hd__decap_4
XFILLER_24_186 VGND VGND VPWR VPWR sky130_fd_sc_hd__fill_1
XTAP_TAPCELL_ROW_35_671 VGND VPWR sky130_fd_sc_hd__tapvpwrvgnd_1
XFILLER_40_657 VPWR VGND VPWR VGND sky130_ef_sc_hd__decap_12
XFILLER_115_3 VPWR VGND VPWR VGND sky130_ef_sc_hd__decap_12
XFILLER_4_525 VGND VGND VPWR VPWR sky130_fd_sc_hd__decap_6
XPHY_EDGE_ROW_65_Left_182 VGND VGND VPWR VPWR sky130_fd_sc_hd__decap_3
XFILLER_4_569 VPWR VGND VPWR VGND sky130_ef_sc_hd__decap_12
XFILLER_97_57 VPWR VGND VPWR VGND sky130_ef_sc_hd__decap_12
XFILLER_79_337 VGND VGND VPWR VPWR sky130_fd_sc_hd__fill_1
XTAP_TAPCELL_ROW_7_341 VGND VPWR sky130_fd_sc_hd__tapvpwrvgnd_1
XTAP_TAPCELL_ROW_7_330 VGND VPWR sky130_fd_sc_hd__tapvpwrvgnd_1
XFILLER_102_681 VGND VGND VPWR VPWR sky130_fd_sc_hd__decap_8
XFILLER_47_256 VGND VGND VPWR VPWR sky130_fd_sc_hd__decap_4
XPHY_EDGE_ROW_74_Left_191 VGND VGND VPWR VPWR sky130_fd_sc_hd__decap_3
XFILLER_16_643 VGND VGND VPWR VPWR sky130_fd_sc_hd__fill_1
XFILLER_43_495 VGND VGND VPWR VPWR sky130_fd_sc_hd__decap_8
XFILLER_62_71 VGND VGND VPWR VPWR sky130_fd_sc_hd__fill_2
XTAP_TAPCELL_ROW_96_1404 VGND VPWR sky130_fd_sc_hd__tapvpwrvgnd_1
XFILLER_7_55 VGND VGND VPWR VPWR sky130_fd_sc_hd__fill_1
X_4390_ _0120_ _0156_ VGND VGND VPWR VPWR _0157_ sky130_fd_sc_hd__and2_1
X_3410_ net362 VGND VGND VPWR VPWR _0819_ sky130_fd_sc_hd__inv_2
XFILLER_7_385 VGND VGND VPWR VPWR sky130_fd_sc_hd__decap_6
XFILLER_98_613 VPWR VGND VPWR VGND sky130_ef_sc_hd__decap_12
XFILLER_98_657 VPWR VGND VPWR VGND sky130_ef_sc_hd__decap_12
XFILLER_112_445 VPWR VGND VPWR VGND sky130_ef_sc_hd__decap_12
XFILLER_97_167 VGND VGND VPWR VPWR sky130_fd_sc_hd__fill_1
X_6060_ net174 net336 _1908_ _1911_ VGND VGND VPWR VPWR _1913_ sky130_fd_sc_hd__a22o_1
XFILLER_30_3 VPWR VGND VPWR VGND sky130_ef_sc_hd__decap_12
XFILLER_112_489 VPWR VGND VPWR VGND sky130_ef_sc_hd__decap_12
X_5011_ _0643_ _0768_ _0769_ VGND VGND VPWR VPWR _0770_ sky130_fd_sc_hd__nor3_4
XFILLER_66_554 VGND VGND VPWR VPWR sky130_fd_sc_hd__decap_6
XFILLER_93_373 VPWR VGND VPWR VGND sky130_ef_sc_hd__decap_12
XFILLER_53_204 VPWR VGND VPWR VGND sky130_ef_sc_hd__decap_12
XTAP_TAPCELL_ROW_105_1511 VGND VPWR sky130_fd_sc_hd__tapvpwrvgnd_1
X_6893_ net181 _alu_i0.Datapath_i.fu_alu_33673_33851.out1\[19\] VGND VGND VPWR VPWR
+ _alu_i0.Datapath_i.reg_0.reg_out1\[19\] sky130_fd_sc_hd__dfxtp_1
X_5913_ _1597_ _1605_ _1751_ VGND VGND VPWR VPWR _1753_ sky130_fd_sc_hd__and3_1
XFILLER_22_613 VPWR VGND VPWR VGND sky130_ef_sc_hd__decap_12
X_5844_ net168 net466 net206 net199 VGND VGND VPWR VPWR _1678_ sky130_fd_sc_hd__nand4_1
XFILLER_61_281 VPWR VGND VPWR VGND sky130_ef_sc_hd__decap_12
XFILLER_22_657 VPWR VGND VPWR VGND sky130_ef_sc_hd__decap_12
XTAP_TAPCELL_ROW_32_630 VGND VPWR sky130_fd_sc_hd__tapvpwrvgnd_1
XTAP_TAPCELL_ROW_32_641 VGND VPWR sky130_fd_sc_hd__tapvpwrvgnd_1
XTAP_TAPCELL_ROW_60_972 VGND VPWR sky130_fd_sc_hd__tapvpwrvgnd_1
X_5775_ net375 net302 VGND VGND VPWR VPWR _1602_ sky130_fd_sc_hd__nand2_1
XFILLER_21_167 VGND VGND VPWR VPWR sky130_fd_sc_hd__fill_1
X_4726_ _0485_ _0486_ VGND VGND VPWR VPWR _0487_ sky130_fd_sc_hd__nand2b_1
XFILLER_21_189 VGND VGND VPWR VPWR sky130_fd_sc_hd__fill_1
XFILLER_107_217 VGND VGND VPWR VPWR sky130_fd_sc_hd__decap_6
X_4657_ _0362_ _0364_ VGND VGND VPWR VPWR _0419_ sky130_fd_sc_hd__nand2_1
XTAP_TAPCELL_ROW_116_1651 VGND VPWR sky130_fd_sc_hd__tapvpwrvgnd_1
XTAP_TAPCELL_ROW_116_1640 VGND VPWR sky130_fd_sc_hd__tapvpwrvgnd_1
X_3608_ _2717_ _2797_ _2809_ _2811_ net127 VGND VGND VPWR VPWR _2812_ sky130_fd_sc_hd__o311a_1
X_4588_ _0349_ _0350_ VGND VGND VPWR VPWR _0351_ sky130_fd_sc_hd__or2_1
X_6327_ net374 net271 net268 net390 VGND VGND VPWR VPWR _2205_ sky130_fd_sc_hd__a22oi_1
XFILLER_1_517 VPWR VGND VPWR VGND sky130_ef_sc_hd__decap_12
X_3539_ net346 _0906_ _2215_ VGND VGND VPWR VPWR _2226_ sky130_fd_sc_hd__o21a_1
XFILLER_107_78 VPWR VGND VPWR VGND sky130_ef_sc_hd__decap_12
XFILLER_67_27 VPWR VGND VPWR VGND sky130_ef_sc_hd__decap_12
XTAP_TAPCELL_ROW_4_300 VGND VPWR sky130_fd_sc_hd__tapvpwrvgnd_1
X_6258_ _1972_ _1974_ VGND VGND VPWR VPWR _2130_ sky130_fd_sc_hd__nand2_1
X_5209_ _0876_ _0878_ _0982_ _0985_ VGND VGND VPWR VPWR _0986_ sky130_fd_sc_hd__a211o_1
X_6189_ _2050_ _2052_ _2053_ VGND VGND VPWR VPWR _2054_ sky130_fd_sc_hd__nand3_2
XFILLER_83_15 VPWR VGND VPWR VGND sky130_ef_sc_hd__decap_12
XFILLER_44_237 VPWR VGND VPWR VGND sky130_ef_sc_hd__decap_12
XFILLER_16_53 VGND VGND VPWR VPWR sky130_fd_sc_hd__decap_8
XTAP_TAPCELL_ROW_80_1216 VGND VPWR sky130_fd_sc_hd__tapvpwrvgnd_1
XFILLER_9_617 VPWR VGND VPWR VGND sky130_ef_sc_hd__decap_12
XFILLER_12_189 VGND VGND VPWR VPWR sky130_fd_sc_hd__decap_6
XFILLER_8_138 VGND VGND VPWR VPWR sky130_fd_sc_hd__fill_2
XFILLER_32_41 VPWR VGND VPWR VGND sky130_ef_sc_hd__decap_12
XTAP_TAPCELL_ROW_10_368 VGND VPWR sky130_fd_sc_hd__tapvpwrvgnd_1
XFILLER_32_85 VGND VGND VPWR VPWR sky130_fd_sc_hd__decap_4
XFILLER_4_333 VGND VGND VPWR VPWR sky130_fd_sc_hd__fill_1
XFILLER_113_209 VPWR VGND VPWR VGND sky130_ef_sc_hd__decap_12
XTAP_TAPCELL_ROW_78_1189 VGND VPWR sky130_fd_sc_hd__tapvpwrvgnd_1
XTAP_TAPCELL_ROW_91_1345 VGND VPWR sky130_fd_sc_hd__tapvpwrvgnd_1
XFILLER_79_156 VGND VGND VPWR VPWR sky130_fd_sc_hd__fill_2
XFILLER_94_115 VGND VGND VPWR VPWR sky130_fd_sc_hd__decap_3
XFILLER_0_561 VPWR VGND VPWR VGND sky130_ef_sc_hd__decap_12
XFILLER_94_137 VGND VGND VPWR VPWR sky130_fd_sc_hd__decap_3
XFILLER_57_60 VPWR VGND VPWR VGND sky130_ef_sc_hd__decap_12
XFILLER_90_321 VPWR VGND VPWR VGND sky130_ef_sc_hd__decap_12
XFILLER_90_365 VPWR VGND VPWR VGND sky130_ef_sc_hd__decap_12
XFILLER_63_568 VGND VGND VPWR VPWR sky130_fd_sc_hd__decap_3
XTAP_TAPCELL_ROW_18_468 VGND VPWR sky130_fd_sc_hd__tapvpwrvgnd_1
XFILLER_73_81 VGND VGND VPWR VPWR sky130_fd_sc_hd__fill_2
XTAP_TAPCELL_ROW_46_799 VGND VPWR sky130_fd_sc_hd__tapvpwrvgnd_1
X_3890_ _3058_ _3080_ _3075_ VGND VGND VPWR VPWR _3083_ sky130_fd_sc_hd__o21a_1
XFILLER_43_281 VGND VGND VPWR VPWR sky130_fd_sc_hd__fill_2
XTAP_TAPCELL_ROW_100_1452 VGND VPWR sky130_fd_sc_hd__tapvpwrvgnd_1
XFILLER_78_3 VPWR VGND VPWR VGND sky130_ef_sc_hd__decap_12
X_5560_ _1363_ _1365_ _1354_ VGND VGND VPWR VPWR _1368_ sky130_fd_sc_hd__a21oi_1
X_4511_ _0274_ _0275_ _0217_ VGND VGND VPWR VPWR _0276_ sky130_fd_sc_hd__o21ai_1
X_5491_ net389 net320 _1173_ _1175_ VGND VGND VPWR VPWR _1293_ sky130_fd_sc_hd__a31o_1
X_4442_ _0203_ _0204_ _0205_ VGND VGND VPWR VPWR _0208_ sky130_fd_sc_hd__a21o_1
XFILLER_7_193 VPWR VGND VPWR VGND sky130_ef_sc_hd__decap_12
XFILLER_104_209 VGND VGND VPWR VPWR sky130_fd_sc_hd__decap_8
X_4373_ _0109_ _0138_ _0139_ VGND VGND VPWR VPWR _0141_ sky130_fd_sc_hd__and3_1
XFILLER_98_421 VGND VGND VPWR VPWR sky130_fd_sc_hd__fill_2
XFILLER_98_465 VGND VGND VPWR VPWR sky130_fd_sc_hd__fill_1
X_6112_ net168 net192 _1760_ _1759_ VGND VGND VPWR VPWR _1970_ sky130_fd_sc_hd__a31o_1
XFILLER_112_253 VGND VGND VPWR VPWR sky130_fd_sc_hd__decap_8
XTAP_TAPCELL_ROW_111_1581 VGND VPWR sky130_fd_sc_hd__tapvpwrvgnd_1
X_6043_ _1732_ _1892_ _1893_ VGND VGND VPWR VPWR _1894_ sky130_fd_sc_hd__nand3_2
XFILLER_85_148 VGND VGND VPWR VPWR sky130_fd_sc_hd__fill_2
XTAP_TAPCELL_ROW_37_700 VGND VPWR sky130_fd_sc_hd__tapvpwrvgnd_1
XFILLER_93_181 VPWR VGND VPWR VGND sky130_ef_sc_hd__decap_12
XFILLER_66_373 VGND VGND VPWR VPWR sky130_fd_sc_hd__fill_1
XFILLER_81_343 VPWR VGND VPWR VGND sky130_ef_sc_hd__decap_12
XFILLER_41_207 VPWR VGND VPWR VGND sky130_ef_sc_hd__decap_12
X_6876_ net180 _alu_i0.Datapath_i.fu_alu_33673_33851.out1\[2\] VGND VGND VPWR VPWR
+ _alu_i0.Datapath_i.reg_0.reg_out1\[2\] sky130_fd_sc_hd__dfxtp_1
XFILLER_22_421 VPWR VGND VPWR VGND sky130_ef_sc_hd__decap_12
XFILLER_22_465 VGND VGND VPWR VPWR sky130_fd_sc_hd__fill_2
X_5827_ net224 net449 net446 net237 VGND VGND VPWR VPWR _1660_ sky130_fd_sc_hd__a22o_1
X_5758_ _1582_ _1584_ VGND VGND VPWR VPWR _1585_ sky130_fd_sc_hd__xnor2_1
X_4709_ _0466_ _0467_ _0468_ VGND VGND VPWR VPWR _0471_ sky130_fd_sc_hd__a21oi_1
X_5689_ _1507_ _1508_ _1500_ VGND VGND VPWR VPWR _1509_ sky130_fd_sc_hd__a21o_1
XFILLER_78_15 VPWR VGND VPWR VGND sky130_ef_sc_hd__decap_12
XFILLER_78_37 VGND VGND VPWR VPWR sky130_fd_sc_hd__decap_3
XFILLER_103_220 VGND VGND VPWR VPWR sky130_fd_sc_hd__decap_4
XFILLER_49_318 VGND VGND VPWR VPWR sky130_fd_sc_hd__fill_1
XFILLER_85_671 VGND VGND VPWR VPWR sky130_fd_sc_hd__fill_1
XFILLER_57_362 VGND VGND VPWR VPWR sky130_fd_sc_hd__decap_3
XFILLER_72_365 VGND VGND VPWR VPWR sky130_fd_sc_hd__decap_8
XFILLER_72_354 VGND VGND VPWR VPWR sky130_fd_sc_hd__decap_8
XFILLER_17_248 VGND VGND VPWR VPWR sky130_fd_sc_hd__fill_2
XFILLER_45_579 VGND VGND VPWR VPWR sky130_fd_sc_hd__decap_8
XFILLER_72_387 VPWR VGND VPWR VGND sky130_ef_sc_hd__decap_12
XFILLER_13_421 VPWR VGND VPWR VGND sky130_ef_sc_hd__decap_12
XTAP_TAPCELL_ROW_15_427 VGND VPWR sky130_fd_sc_hd__tapvpwrvgnd_1
XTAP_TAPCELL_ROW_43_769 VGND VPWR sky130_fd_sc_hd__tapvpwrvgnd_1
XFILLER_13_476 VPWR VGND VPWR VGND sky130_ef_sc_hd__decap_12
XFILLER_40_251 VGND VGND VPWR VPWR sky130_fd_sc_hd__fill_1
XFILLER_43_95 VPWR VGND VPWR VGND sky130_ef_sc_hd__decap_12
XFILLER_9_469 VGND VGND VPWR VPWR sky130_fd_sc_hd__fill_1
XFILLER_5_653 VPWR VGND VPWR VGND sky130_ef_sc_hd__decap_12
XFILLER_4_141 VPWR VGND VPWR VGND sky130_ef_sc_hd__decap_12
XFILLER_68_70 VPWR VGND VPWR VGND sky130_ef_sc_hd__decap_12
XFILLER_67_104 VGND VGND VPWR VPWR sky130_fd_sc_hd__decap_8
XFILLER_95_446 VGND VGND VPWR VPWR sky130_fd_sc_hd__fill_2
XFILLER_83_608 VGND VGND VPWR VPWR sky130_fd_sc_hd__decap_8
XFILLER_75_181 VPWR VGND VPWR VGND sky130_ef_sc_hd__decap_12
XFILLER_48_395 VPWR VGND VPWR VGND sky130_ef_sc_hd__decap_12
XFILLER_91_641 VPWR VGND VPWR VGND sky130_ef_sc_hd__decap_12
XFILLER_36_579 VGND VGND VPWR VPWR sky130_fd_sc_hd__decap_4
X_4991_ _0664_ _0667_ VGND VGND VPWR VPWR _0749_ sky130_fd_sc_hd__nand2_1
XFILLER_91_685 VGND VGND VPWR VPWR sky130_fd_sc_hd__decap_6
X_6730_ _2599_ _2644_ VGND VGND VPWR VPWR _2645_ sky130_fd_sc_hd__xor2_1
XFILLER_23_218 VGND VGND VPWR VPWR sky130_fd_sc_hd__decap_6
X_3942_ net132 _3115_ _3132_ _1539_ VGND VGND VPWR VPWR _3133_ sky130_fd_sc_hd__a211oi_1
X_3873_ net151 _3066_ VGND VGND VPWR VPWR _3067_ sky130_fd_sc_hd__nand2_1
X_6661_ _2567_ _2568_ VGND VGND VPWR VPWR _2569_ sky130_fd_sc_hd__xor2_1
X_5612_ _1422_ _1423_ _1424_ VGND VGND VPWR VPWR _1425_ sky130_fd_sc_hd__nand3_2
X_6592_ _alu_i0.Datapath_i.reg_0.reg_out1\[29\] _2493_ net147 VGND VGND VPWR VPWR
+ net98 sky130_fd_sc_hd__mux2_1
X_5543_ _1347_ _1348_ VGND VGND VPWR VPWR _1349_ sky130_fd_sc_hd__nand2b_1
X_5474_ net309 net186 net341 net384 VGND VGND VPWR VPWR _1274_ sky130_fd_sc_hd__a22oi_1
XTAP_TAPCELL_ROW_113_1610 VGND VPWR sky130_fd_sc_hd__tapvpwrvgnd_1
X_4425_ net415 net214 VGND VGND VPWR VPWR _0191_ sky130_fd_sc_hd__nand2_1
X_4356_ net238 net225 net422 net414 VGND VGND VPWR VPWR _0124_ sky130_fd_sc_hd__nand4_1
Xfanout404 net405 VGND VGND VPWR VPWR net404 sky130_fd_sc_hd__clkbuf_4
XFILLER_113_573 VPWR VGND VPWR VGND sky130_ef_sc_hd__decap_12
Xfanout415 net418 VGND VGND VPWR VPWR net415 sky130_fd_sc_hd__clkbuf_2
XFILLER_98_251 VGND VGND VPWR VPWR sky130_fd_sc_hd__fill_1
Xfanout426 net23 VGND VGND VPWR VPWR net426 sky130_fd_sc_hd__clkbuf_4
Xfanout448 net449 VGND VGND VPWR VPWR net448 sky130_fd_sc_hd__buf_2
Xfanout437 net18 VGND VGND VPWR VPWR net437 sky130_fd_sc_hd__buf_2
XFILLER_100_223 VGND VGND VPWR VPWR sky130_fd_sc_hd__decap_6
X_4287_ _0056_ _0057_ VGND VGND VPWR VPWR _0058_ sky130_fd_sc_hd__nor2_1
Xfanout459 net12 VGND VGND VPWR VPWR net459 sky130_fd_sc_hd__clkbuf_8
X_6026_ _1873_ _1874_ VGND VGND VPWR VPWR _1875_ sky130_fd_sc_hd__and2_1
XFILLER_27_524 VGND VGND VPWR VPWR sky130_fd_sc_hd__decap_4
XFILLER_66_192 VGND VGND VPWR VPWR sky130_fd_sc_hd__decap_4
XTAP_TAPCELL_ROW_64_1019 VGND VPWR sky130_fd_sc_hd__tapvpwrvgnd_1
XFILLER_54_365 VPWR VGND VPWR VGND sky130_ef_sc_hd__decap_12
XFILLER_80_27 VGND VGND VPWR VPWR sky130_fd_sc_hd__fill_1
X_6859_ _2784_ _2785_ VGND VGND VPWR VPWR _2786_ sky130_fd_sc_hd__xnor2_1
XFILLER_50_560 VGND VGND VPWR VPWR sky130_fd_sc_hd__decap_8
XTAP_TAPCELL_ROW_40_728 VGND VPWR sky130_fd_sc_hd__tapvpwrvgnd_1
XFILLER_10_457 VGND VGND VPWR VPWR sky130_fd_sc_hd__fill_1
XFILLER_6_439 VGND VGND VPWR VPWR sky130_fd_sc_hd__decap_8
XTAP_TAPCELL_ROW_20_496 VGND VPWR sky130_fd_sc_hd__tapvpwrvgnd_1
XTAP_TAPCELL_ROW_75_1148 VGND VPWR sky130_fd_sc_hd__tapvpwrvgnd_1
XFILLER_2_601 VPWR VGND VPWR VGND sky130_ef_sc_hd__decap_12
XFILLER_8_3 VPWR VGND VPWR VGND sky130_ef_sc_hd__decap_12
XFILLER_2_645 VPWR VGND VPWR VGND sky130_ef_sc_hd__decap_12
XFILLER_2_689 VGND VGND VPWR VPWR sky130_fd_sc_hd__decap_3
XFILLER_64_107 VGND VGND VPWR VPWR sky130_fd_sc_hd__fill_1
XFILLER_64_129 VGND VGND VPWR VPWR sky130_fd_sc_hd__decap_4
XFILLER_38_95 VGND VGND VPWR VPWR sky130_fd_sc_hd__decap_8
XTAP_TAPCELL_ROW_48_828 VGND VPWR sky130_fd_sc_hd__tapvpwrvgnd_1
XFILLER_18_568 VPWR VGND VPWR VGND sky130_ef_sc_hd__decap_12
XTAP_TAPCELL_ROW_86_1288 VGND VPWR sky130_fd_sc_hd__tapvpwrvgnd_1
XFILLER_73_685 VGND VGND VPWR VPWR sky130_fd_sc_hd__decap_6
XFILLER_60_302 VGND VGND VPWR VPWR sky130_fd_sc_hd__fill_1
XFILLER_33_505 VGND VGND VPWR VPWR sky130_fd_sc_hd__decap_8
XFILLER_72_195 VGND VGND VPWR VPWR sky130_fd_sc_hd__fill_1
XTAP_TAPCELL_ROW_28_585 VGND VPWR sky130_fd_sc_hd__tapvpwrvgnd_1
XFILLER_114_326 VGND VGND VPWR VPWR sky130_fd_sc_hd__decap_8
XFILLER_5_461 VPWR VGND VPWR VGND sky130_ef_sc_hd__decap_12
X_4210_ _3044_ _3134_ _3307_ _2858_ _3388_ VGND VGND VPWR VPWR _3389_ sky130_fd_sc_hd__a221o_1
XPHY_EDGE_ROW_10_Left_127 VGND VGND VPWR VPWR sky130_fd_sc_hd__decap_3
X_5190_ _0963_ _0964_ VGND VGND VPWR VPWR _0965_ sky130_fd_sc_hd__nor2_1
X_4141_ net140 _3320_ _3321_ _3322_ VGND VGND VPWR VPWR _3323_ sky130_fd_sc_hd__or4_1
XFILLER_83_405 VGND VGND VPWR VPWR sky130_fd_sc_hd__decap_6
XFILLER_56_619 VPWR VGND VPWR VGND sky130_ef_sc_hd__decap_12
X_4072_ net135 _3246_ net129 VGND VGND VPWR VPWR _3257_ sky130_fd_sc_hd__o21ai_1
XFILLER_110_587 VGND VGND VPWR VPWR sky130_fd_sc_hd__fill_1
XFILLER_83_449 VGND VGND VPWR VPWR sky130_fd_sc_hd__decap_6
XFILLER_83_427 VGND VGND VPWR VPWR sky130_fd_sc_hd__fill_1
XFILLER_48_170 VGND VGND VPWR VPWR sky130_fd_sc_hd__decap_8
XFILLER_49_671 VGND VGND VPWR VPWR sky130_fd_sc_hd__fill_1
XFILLER_36_365 VPWR VGND VPWR VGND sky130_ef_sc_hd__decap_12
XFILLER_51_302 VGND VGND VPWR VPWR sky130_fd_sc_hd__decap_8
X_4974_ _0647_ _0655_ _0654_ VGND VGND VPWR VPWR _0732_ sky130_fd_sc_hd__o21ba_1
XFILLER_24_549 VPWR VGND VPWR VGND sky130_ef_sc_hd__decap_12
XFILLER_51_324 VGND VGND VPWR VPWR sky130_fd_sc_hd__decap_8
XFILLER_51_335 VGND VGND VPWR VPWR sky130_fd_sc_hd__fill_1
X_3925_ _3024_ _3050_ _3048_ VGND VGND VPWR VPWR _3116_ sky130_fd_sc_hd__a21oi_1
X_6713_ _2624_ _2625_ VGND VGND VPWR VPWR _2626_ sky130_fd_sc_hd__xnor2_1
XFILLER_51_368 VPWR VGND VPWR VGND sky130_ef_sc_hd__decap_12
X_6644_ _2525_ _2548_ VGND VGND VPWR VPWR _2550_ sky130_fd_sc_hd__xnor2_1
X_3856_ net261 net328 VGND VGND VPWR VPWR _3050_ sky130_fd_sc_hd__or2_1
X_3787_ _2945_ _2946_ _2963_ _2942_ VGND VGND VPWR VPWR _2984_ sky130_fd_sc_hd__a211o_1
X_6575_ _2300_ _2302_ _2474_ _2475_ VGND VGND VPWR VPWR _2476_ sky130_fd_sc_hd__a211o_1
X_5526_ _1202_ _1204_ _1328_ _1329_ VGND VGND VPWR VPWR _1331_ sky130_fd_sc_hd__o211ai_1
X_5457_ _1252_ _1253_ _1188_ VGND VGND VPWR VPWR _1256_ sky130_fd_sc_hd__o21a_1
X_4408_ _0138_ _0174_ VGND VGND VPWR VPWR _0175_ sky130_fd_sc_hd__nor2_1
XFILLER_105_337 VPWR VGND VPWR VGND sky130_ef_sc_hd__decap_12
Xfanout201 net204 VGND VGND VPWR VPWR net201 sky130_fd_sc_hd__buf_2
Xfanout223 net224 VGND VGND VPWR VPWR net223 sky130_fd_sc_hd__buf_2
X_5388_ _1172_ _1178_ VGND VGND VPWR VPWR _1181_ sky130_fd_sc_hd__xor2_1
Xfanout212 net213 VGND VGND VPWR VPWR net212 sky130_fd_sc_hd__clkbuf_4
X_4339_ _1746_ _0107_ VGND VGND VPWR VPWR _0108_ sky130_fd_sc_hd__xor2_1
Xfanout245 net248 VGND VGND VPWR VPWR net245 sky130_fd_sc_hd__clkbuf_4
Xfanout234 net243 VGND VGND VPWR VPWR net234 sky130_fd_sc_hd__buf_2
Xfanout256 net257 VGND VGND VPWR VPWR net256 sky130_fd_sc_hd__buf_2
Xfanout289 net291 VGND VGND VPWR VPWR net289 sky130_fd_sc_hd__clkbuf_4
XFILLER_75_27 VGND VGND VPWR VPWR sky130_fd_sc_hd__fill_1
XTAP_TAPCELL_ROW_70_1089 VGND VPWR sky130_fd_sc_hd__tapvpwrvgnd_1
Xfanout278 net279 VGND VGND VPWR VPWR net278 sky130_fd_sc_hd__clkbuf_4
Xfanout267 net48 VGND VGND VPWR VPWR net267 sky130_fd_sc_hd__clkbuf_4
XFILLER_86_276 VPWR VGND VPWR VGND sky130_ef_sc_hd__decap_12
XFILLER_75_49 VGND VGND VPWR VPWR sky130_fd_sc_hd__fill_1
X_6009_ _1856_ _1857_ _1711_ _1715_ VGND VGND VPWR VPWR _1858_ sky130_fd_sc_hd__o211ai_2
XFILLER_55_641 VPWR VGND VPWR VGND sky130_ef_sc_hd__decap_12
XFILLER_39_181 VGND VGND VPWR VPWR sky130_fd_sc_hd__decap_8
XFILLER_55_685 VGND VGND VPWR VPWR sky130_fd_sc_hd__fill_1
XFILLER_15_505 VGND VGND VPWR VPWR sky130_fd_sc_hd__decap_8
XTAP_TAPCELL_ROW_25_555 VGND VPWR sky130_fd_sc_hd__tapvpwrvgnd_1
XTAP_TAPCELL_ROW_53_886 VGND VPWR sky130_fd_sc_hd__tapvpwrvgnd_1
XFILLER_24_97 VPWR VGND VPWR VGND sky130_ef_sc_hd__decap_12
XFILLER_109_665 VGND VGND VPWR VPWR sky130_fd_sc_hd__decap_6
XFILLER_10_298 VGND VGND VPWR VPWR sky130_fd_sc_hd__decap_8
XFILLER_40_41 VGND VGND VPWR VPWR sky130_fd_sc_hd__decap_8
XFILLER_40_85 VGND VGND VPWR VPWR sky130_fd_sc_hd__decap_3
XFILLER_108_197 VGND VGND VPWR VPWR sky130_fd_sc_hd__fill_1
XFILLER_97_519 VGND VGND VPWR VPWR sky130_fd_sc_hd__fill_1
XFILLER_111_329 VGND VGND VPWR VPWR sky130_fd_sc_hd__decap_6
XFILLER_77_221 VGND VGND VPWR VPWR sky130_fd_sc_hd__decap_3
XTAP_TAPCELL_ROW_88_1306 VGND VPWR sky130_fd_sc_hd__tapvpwrvgnd_1
XFILLER_65_405 VGND VGND VPWR VPWR sky130_fd_sc_hd__decap_6
XFILLER_38_608 VPWR VGND VPWR VGND sky130_ef_sc_hd__decap_12
XFILLER_77_298 VPWR VGND VPWR VGND sky130_ef_sc_hd__decap_12
XFILLER_92_246 VGND VGND VPWR VPWR sky130_fd_sc_hd__fill_1
XFILLER_65_449 VPWR VGND VPWR VGND sky130_ef_sc_hd__decap_12
XFILLER_1_57 VPWR VGND VPWR VGND sky130_ef_sc_hd__decap_12
XFILLER_18_321 VPWR VGND VPWR VGND sky130_ef_sc_hd__decap_12
XFILLER_80_408 VPWR VGND VPWR VGND sky130_ef_sc_hd__decap_12
XFILLER_18_365 VGND VGND VPWR VPWR sky130_fd_sc_hd__decap_4
XFILLER_33_335 VGND VGND VPWR VPWR sky130_fd_sc_hd__fill_1
XFILLER_21_519 VGND VGND VPWR VPWR sky130_fd_sc_hd__decap_8
X_3710_ _2908_ _2910_ net236 VGND VGND VPWR VPWR _2911_ sky130_fd_sc_hd__mux2_1
X_4690_ _0448_ _0449_ _0381_ VGND VGND VPWR VPWR _0452_ sky130_fd_sc_hd__a21bo_1
XTAP_TAPCELL_ROW_99_1435 VGND VPWR sky130_fd_sc_hd__tapvpwrvgnd_1
XFILLER_81_92 VGND VGND VPWR VPWR sky130_fd_sc_hd__decap_4
X_3641_ _2842_ _2843_ VGND VGND VPWR VPWR _2844_ sky130_fd_sc_hd__nor2_1
X_3572_ _1681_ _1299_ net289 VGND VGND VPWR VPWR _2586_ sky130_fd_sc_hd__mux2_1
X_6360_ _2239_ _2240_ VGND VGND VPWR VPWR _2241_ sky130_fd_sc_hd__or2_1
X_5311_ _0991_ _0996_ _0990_ VGND VGND VPWR VPWR _1097_ sky130_fd_sc_hd__a21bo_1
X_6291_ _1962_ _1966_ _2164_ _2165_ VGND VGND VPWR VPWR _2166_ sky130_fd_sc_hd__a211oi_1
X_5242_ _1016_ _1019_ _1020_ VGND VGND VPWR VPWR _1021_ sky130_fd_sc_hd__nand3_2
XFILLER_114_189 VGND VGND VPWR VPWR sky130_fd_sc_hd__decap_6
X_5173_ net379 net337 VGND VGND VPWR VPWR _0946_ sky130_fd_sc_hd__and2_1
X_4124_ net233 _1725_ VGND VGND VPWR VPWR _3307_ sky130_fd_sc_hd__nor2_2
Xinput1 a[0] VGND VGND VPWR VPWR net1 sky130_fd_sc_hd__clkbuf_2
XFILLER_110_395 VPWR VGND VPWR VGND sky130_ef_sc_hd__decap_12
X_4055_ _3154_ _3240_ net159 VGND VGND VPWR VPWR _3241_ sky130_fd_sc_hd__mux2_1
XFILLER_37_641 VPWR VGND VPWR VGND sky130_ef_sc_hd__decap_12
XTAP_TAPCELL_ROW_108_1553 VGND VPWR sky130_fd_sc_hd__tapvpwrvgnd_1
XTAP_TAPCELL_ROW_108_1542 VGND VPWR sky130_fd_sc_hd__tapvpwrvgnd_1
XFILLER_83_279 VGND VGND VPWR VPWR sky130_fd_sc_hd__fill_1
XFILLER_37_685 VGND VGND VPWR VPWR sky130_fd_sc_hd__decap_6
XFILLER_24_313 VGND VGND VPWR VPWR sky130_fd_sc_hd__decap_8
XFILLER_36_173 VGND VGND VPWR VPWR sky130_fd_sc_hd__fill_1
XFILLER_36_195 VGND VGND VPWR VPWR sky130_fd_sc_hd__fill_1
XFILLER_24_357 VGND VGND VPWR VPWR sky130_fd_sc_hd__decap_6
XFILLER_24_379 VGND VGND VPWR VPWR sky130_fd_sc_hd__fill_1
XFILLER_101_69 VGND VGND VPWR VPWR sky130_fd_sc_hd__decap_3
X_4957_ _2943_ _0714_ VGND VGND VPWR VPWR _0715_ sky130_fd_sc_hd__xnor2_1
XTAP_TAPCELL_ROW_22_514 VGND VPWR sky130_fd_sc_hd__tapvpwrvgnd_1
X_4888_ net290 net221 VGND VGND VPWR VPWR _0647_ sky130_fd_sc_hd__nand2_1
XTAP_TAPCELL_ROW_50_856 VGND VPWR sky130_fd_sc_hd__tapvpwrvgnd_1
X_3908_ net126 _3093_ _3098_ net140 VGND VGND VPWR VPWR _3100_ sky130_fd_sc_hd__o2bb2a_1
X_3839_ _3031_ _3033_ VGND VGND VPWR VPWR _3034_ sky130_fd_sc_hd__or2_1
XFILLER_20_585 VGND VGND VPWR VPWR sky130_fd_sc_hd__decap_3
X_6627_ _2529_ _2530_ VGND VGND VPWR VPWR _2532_ sky130_fd_sc_hd__xor2_1
X_6558_ _2451_ _2457_ VGND VGND VPWR VPWR _2458_ sky130_fd_sc_hd__nand2b_1
XFILLER_106_613 VPWR VGND VPWR VGND sky130_ef_sc_hd__decap_12
XFILLER_106_657 VPWR VGND VPWR VGND sky130_ef_sc_hd__decap_12
X_5509_ _1273_ _1311_ _1312_ VGND VGND VPWR VPWR _1313_ sky130_fd_sc_hd__and3_1
X_6489_ _2196_ _2220_ _2380_ _2381_ VGND VGND VPWR VPWR _2382_ sky130_fd_sc_hd__o211ai_1
XFILLER_105_167 VGND VGND VPWR VPWR sky130_fd_sc_hd__fill_1
XTAP_TAPCELL_ROW_72_1118 VGND VPWR sky130_fd_sc_hd__tapvpwrvgnd_1
XFILLER_86_15 VPWR VGND VPWR VGND sky130_ef_sc_hd__decap_12
XFILLER_59_254 VGND VGND VPWR VPWR sky130_fd_sc_hd__fill_1
XFILLER_47_405 VPWR VGND VPWR VGND sky130_ef_sc_hd__decap_12
XTAP_TAPCELL_ROW_58_945 VGND VPWR sky130_fd_sc_hd__tapvpwrvgnd_1
XFILLER_19_75 VGND VGND VPWR VPWR sky130_fd_sc_hd__decap_6
XFILLER_47_449 VGND VGND VPWR VPWR sky130_fd_sc_hd__decap_6
XTAP_TAPCELL_ROW_2_272 VGND VPWR sky130_fd_sc_hd__tapvpwrvgnd_1
XFILLER_15_335 VGND VGND VPWR VPWR sky130_fd_sc_hd__fill_1
XTAP_TAPCELL_ROW_83_1247 VGND VPWR sky130_fd_sc_hd__tapvpwrvgnd_1
XFILLER_42_187 VGND VGND VPWR VPWR sky130_fd_sc_hd__decap_8
XFILLER_11_541 VPWR VGND VPWR VGND sky130_ef_sc_hd__decap_12
XFILLER_30_349 VPWR VGND VPWR VGND sky130_ef_sc_hd__decap_12
XFILLER_11_585 VPWR VGND VPWR VGND sky130_ef_sc_hd__decap_12
XFILLER_51_73 VPWR VGND VPWR VGND sky130_ef_sc_hd__decap_12
XFILLER_109_473 VGND VGND VPWR VPWR sky130_fd_sc_hd__decap_8
XTAP_TAPCELL_ROW_94_1376 VGND VPWR sky130_fd_sc_hd__tapvpwrvgnd_1
XFILLER_2_250 VGND VGND VPWR VPWR sky130_fd_sc_hd__fill_2
XFILLER_111_126 VGND VGND VPWR VPWR sky130_fd_sc_hd__decap_3
XFILLER_38_427 VPWR VGND VPWR VGND sky130_ef_sc_hd__decap_12
XFILLER_76_81 VGND VGND VPWR VPWR sky130_fd_sc_hd__decap_3
XFILLER_19_641 VPWR VGND VPWR VGND sky130_ef_sc_hd__decap_12
XFILLER_65_268 VPWR VGND VPWR VGND sky130_ef_sc_hd__decap_12
XFILLER_19_685 VGND VGND VPWR VPWR sky130_fd_sc_hd__decap_6
XFILLER_80_227 VGND VGND VPWR VPWR sky130_fd_sc_hd__decap_4
X_5860_ _1694_ _1695_ _1674_ VGND VGND VPWR VPWR _1696_ sky130_fd_sc_hd__a21oi_1
X_4811_ _0567_ _0568_ _0569_ VGND VGND VPWR VPWR _0571_ sky130_fd_sc_hd__a21oi_1
XFILLER_33_121 VGND VGND VPWR VPWR sky130_fd_sc_hd__fill_2
XFILLER_21_305 VPWR VGND VPWR VGND sky130_ef_sc_hd__decap_12
X_5791_ net309 net331 net325 net383 VGND VGND VPWR VPWR _1620_ sky130_fd_sc_hd__a22o_1
XFILLER_33_165 VGND VGND VPWR VPWR sky130_fd_sc_hd__decap_3
XTAP_TAPCELL_ROW_103_1483 VGND VPWR sky130_fd_sc_hd__tapvpwrvgnd_1
X_4742_ net356 net260 _0502_ VGND VGND VPWR VPWR _0503_ sky130_fd_sc_hd__and3_1
X_4673_ _0377_ _0379_ VGND VGND VPWR VPWR _0435_ sky130_fd_sc_hd__nand2_1
X_3624_ _2292_ _2325_ net284 VGND VGND VPWR VPWR _2828_ sky130_fd_sc_hd__mux2_1
X_6412_ _2137_ _2140_ _2295_ _2297_ VGND VGND VPWR VPWR _2298_ sky130_fd_sc_hd__a211o_2
X_3555_ net354 net423 VGND VGND VPWR VPWR _2401_ sky130_fd_sc_hd__nand2_1
X_6343_ _2034_ _2063_ _2220_ _2221_ VGND VGND VPWR VPWR _2222_ sky130_fd_sc_hd__a211oi_2
X_3486_ net356 net260 VGND VGND VPWR VPWR _1648_ sky130_fd_sc_hd__nand2_1
X_6274_ _2146_ VGND VGND VPWR VPWR _2147_ sky130_fd_sc_hd__inv_2
XFILLER_88_349 VPWR VGND VPWR VGND sky130_ef_sc_hd__decap_12
X_5225_ net246 net167 _1000_ _1001_ VGND VGND VPWR VPWR _1002_ sky130_fd_sc_hd__a22o_1
XFILLER_69_552 VGND VGND VPWR VPWR sky130_fd_sc_hd__decap_3
XFILLER_111_671 VGND VGND VPWR VPWR sky130_fd_sc_hd__fill_1
X_5156_ _0925_ _0926_ _0907_ VGND VGND VPWR VPWR _0927_ sky130_fd_sc_hd__a21oi_1
XFILLER_56_213 VPWR VGND VPWR VGND sky130_ef_sc_hd__decap_12
X_5087_ net387 net210 net202 net434 VGND VGND VPWR VPWR _0853_ sky130_fd_sc_hd__a22o_1
X_4107_ _3204_ _3228_ _3286_ _3289_ VGND VGND VPWR VPWR _3290_ sky130_fd_sc_hd__a31o_1
XTAP_TAPCELL_ROW_55_915 VGND VPWR sky130_fd_sc_hd__tapvpwrvgnd_1
X_4038_ net445 net271 VGND VGND VPWR VPWR _3224_ sky130_fd_sc_hd__nand2_1
XFILLER_71_249 VPWR VGND VPWR VGND sky130_ef_sc_hd__decap_12
XTAP_TAPCELL_ROW_69_1080 VGND VPWR sky130_fd_sc_hd__tapvpwrvgnd_1
XFILLER_37_482 VPWR VGND VPWR VGND sky130_ef_sc_hd__decap_12
XFILLER_52_463 VPWR VGND VPWR VGND sky130_ef_sc_hd__decap_12
X_5989_ _1833_ _1834_ _1689_ _1691_ VGND VGND VPWR VPWR _1836_ sky130_fd_sc_hd__o211ai_2
XTAP_TAPCELL_ROW_35_672 VGND VPWR sky130_fd_sc_hd__tapvpwrvgnd_1
XFILLER_40_669 VPWR VGND VPWR VGND sky130_ef_sc_hd__decap_12
XFILLER_108_3 VPWR VGND VPWR VGND sky130_ef_sc_hd__decap_12
XFILLER_106_421 VGND VGND VPWR VPWR sky130_fd_sc_hd__fill_2
XFILLER_79_305 VGND VGND VPWR VPWR sky130_fd_sc_hd__decap_3
XTAP_TAPCELL_ROW_7_331 VGND VPWR sky130_fd_sc_hd__tapvpwrvgnd_1
XFILLER_87_393 VGND VGND VPWR VPWR sky130_fd_sc_hd__decap_8
XFILLER_15_143 VGND VGND VPWR VPWR sky130_fd_sc_hd__fill_2
XFILLER_102_90 VGND VGND VPWR VPWR sky130_fd_sc_hd__fill_2
XFILLER_70_260 VPWR VGND VPWR VGND sky130_ef_sc_hd__decap_12
XFILLER_15_187 VPWR VGND VPWR VGND sky130_ef_sc_hd__decap_12
XTAP_TAPCELL_ROW_96_1405 VGND VPWR sky130_fd_sc_hd__tapvpwrvgnd_1
XFILLER_11_393 VPWR VGND VPWR VGND sky130_ef_sc_hd__decap_12
XFILLER_11_382 VGND VGND VPWR VPWR sky130_fd_sc_hd__decap_8
XFILLER_109_281 VPWR VGND VPWR VGND sky130_ef_sc_hd__decap_12
XFILLER_98_625 VPWR VGND VPWR VGND sky130_ef_sc_hd__decap_12
XFILLER_97_113 VGND VGND VPWR VPWR sky130_fd_sc_hd__decap_8
XFILLER_112_457 VPWR VGND VPWR VGND sky130_ef_sc_hd__decap_12
XFILLER_98_669 VPWR VGND VPWR VGND sky130_ef_sc_hd__decap_12
X_5010_ _0747_ _0764_ _0767_ VGND VGND VPWR VPWR _0769_ sky130_fd_sc_hd__and3_2
XFILLER_23_3 VPWR VGND VPWR VGND sky130_ef_sc_hd__decap_12
XFILLER_66_533 VGND VGND VPWR VPWR sky130_fd_sc_hd__decap_4
XFILLER_81_503 VGND VGND VPWR VPWR sky130_fd_sc_hd__fill_1
XFILLER_66_566 VGND VGND VPWR VPWR sky130_fd_sc_hd__fill_2
XFILLER_26_419 VGND VGND VPWR VPWR sky130_fd_sc_hd__fill_1
XTAP_TAPCELL_ROW_105_1512 VGND VPWR sky130_fd_sc_hd__tapvpwrvgnd_1
XFILLER_93_385 VGND VGND VPWR VPWR sky130_fd_sc_hd__decap_6
XFILLER_53_216 VGND VGND VPWR VPWR sky130_fd_sc_hd__decap_8
XFILLER_81_569 VPWR VGND VPWR VGND sky130_ef_sc_hd__decap_12
X_6892_ net183 _alu_i0.Datapath_i.fu_alu_33673_33851.out1\[18\] VGND VGND VPWR VPWR
+ _alu_i0.Datapath_i.reg_0.reg_out1\[18\] sky130_fd_sc_hd__dfxtp_1
X_5912_ _1597_ _1605_ _1751_ VGND VGND VPWR VPWR _1752_ sky130_fd_sc_hd__a21oi_2
XFILLER_22_625 VPWR VGND VPWR VGND sky130_ef_sc_hd__decap_12
X_5843_ net178 net192 _1485_ _1483_ VGND VGND VPWR VPWR _1677_ sky130_fd_sc_hd__a31o_1
XFILLER_22_669 VPWR VGND VPWR VGND sky130_ef_sc_hd__decap_12
XTAP_TAPCELL_ROW_32_631 VGND VPWR sky130_fd_sc_hd__tapvpwrvgnd_1
XTAP_TAPCELL_ROW_60_973 VGND VPWR sky130_fd_sc_hd__tapvpwrvgnd_1
X_5774_ _1599_ _1600_ VGND VGND VPWR VPWR _1601_ sky130_fd_sc_hd__and2b_1
X_4725_ _0483_ _0484_ _0415_ VGND VGND VPWR VPWR _0486_ sky130_fd_sc_hd__a21o_1
X_4656_ _0412_ _0416_ VGND VGND VPWR VPWR _0418_ sky130_fd_sc_hd__xnor2_1
XTAP_TAPCELL_ROW_116_1652 VGND VPWR sky130_fd_sc_hd__tapvpwrvgnd_1
XTAP_TAPCELL_ROW_116_1641 VGND VPWR sky130_fd_sc_hd__tapvpwrvgnd_1
X_4587_ net474 net338 _0348_ VGND VGND VPWR VPWR _0350_ sky130_fd_sc_hd__a21oi_1
X_3607_ _2809_ _2810_ VGND VGND VPWR VPWR _2811_ sky130_fd_sc_hd__nand2_1
Xinput70 opcode[4] VGND VGND VPWR VPWR net70 sky130_fd_sc_hd__clkbuf_1
XPHY_EDGE_ROW_2_Left_119 VGND VGND VPWR VPWR sky130_fd_sc_hd__decap_3
X_6326_ net390 net374 net271 net268 VGND VGND VPWR VPWR _2203_ sky130_fd_sc_hd__and4_1
X_3538_ net346 net24 VGND VGND VPWR VPWR _2215_ sky130_fd_sc_hd__nand2_2
XFILLER_107_57 VPWR VGND VPWR VGND sky130_ef_sc_hd__decap_12
XFILLER_88_124 VGND VGND VPWR VPWR sky130_fd_sc_hd__decap_8
XFILLER_1_529 VPWR VGND VPWR VGND sky130_ef_sc_hd__decap_12
XFILLER_103_457 VGND VGND VPWR VPWR sky130_fd_sc_hd__fill_2
XFILLER_67_39 VGND VGND VPWR VPWR sky130_fd_sc_hd__decap_4
X_6257_ _1907_ _1916_ _1915_ VGND VGND VPWR VPWR _2129_ sky130_fd_sc_hd__a21o_1
X_3469_ net346 net22 VGND VGND VPWR VPWR _1462_ sky130_fd_sc_hd__nand2_1
X_5208_ _0979_ _0981_ _0869_ _0871_ VGND VGND VPWR VPWR _0985_ sky130_fd_sc_hd__o211a_1
XTAP_TAPCELL_ROW_4_301 VGND VPWR sky130_fd_sc_hd__tapvpwrvgnd_1
X_6188_ _1884_ _1886_ VGND VGND VPWR VPWR _2053_ sky130_fd_sc_hd__nand2_1
XFILLER_97_691 VGND VGND VPWR VPWR sky130_fd_sc_hd__fill_1
X_5139_ _0851_ _0855_ VGND VGND VPWR VPWR _0909_ sky130_fd_sc_hd__nand2_1
XFILLER_69_393 VPWR VGND VPWR VGND sky130_ef_sc_hd__decap_12
XFILLER_29_235 VPWR VGND VPWR VGND sky130_ef_sc_hd__decap_12
XFILLER_84_363 VGND VGND VPWR VPWR sky130_fd_sc_hd__fill_1
XFILLER_29_279 VGND VGND VPWR VPWR sky130_fd_sc_hd__fill_1
XFILLER_83_27 VPWR VGND VPWR VGND sky130_ef_sc_hd__decap_12
XFILLER_44_249 VGND VGND VPWR VPWR sky130_fd_sc_hd__decap_3
XTAP_TAPCELL_ROW_80_1217 VGND VPWR sky130_fd_sc_hd__tapvpwrvgnd_1
XTAP_TAPCELL_ROW_80_1206 VGND VPWR sky130_fd_sc_hd__tapvpwrvgnd_1
XFILLER_9_629 VPWR VGND VPWR VGND sky130_ef_sc_hd__decap_12
XFILLER_40_477 VGND VGND VPWR VPWR sky130_fd_sc_hd__decap_6
XFILLER_32_53 VPWR VGND VPWR VGND sky130_ef_sc_hd__decap_12
XTAP_TAPCELL_ROW_10_369 VGND VPWR sky130_fd_sc_hd__tapvpwrvgnd_1
XFILLER_4_301 VGND VGND VPWR VPWR sky130_fd_sc_hd__fill_1
XTAP_TAPCELL_ROW_91_1346 VGND VPWR sky130_fd_sc_hd__tapvpwrvgnd_1
XFILLER_79_113 VGND VGND VPWR VPWR sky130_fd_sc_hd__fill_1
XFILLER_79_135 VGND VGND VPWR VPWR sky130_fd_sc_hd__decap_6
XFILLER_95_617 VPWR VGND VPWR VGND sky130_ef_sc_hd__decap_12
XFILLER_0_573 VPWR VGND VPWR VGND sky130_ef_sc_hd__decap_12
XFILLER_48_533 VGND VGND VPWR VPWR sky130_fd_sc_hd__fill_2
XFILLER_57_83 VGND VGND VPWR VPWR sky130_fd_sc_hd__decap_8
XFILLER_57_72 VGND VGND VPWR VPWR sky130_fd_sc_hd__decap_4
XFILLER_90_333 VPWR VGND VPWR VGND sky130_ef_sc_hd__decap_12
XFILLER_16_430 VGND VGND VPWR VPWR sky130_fd_sc_hd__decap_4
XFILLER_16_441 VPWR VGND VPWR VGND sky130_ef_sc_hd__decap_12
XFILLER_90_377 VPWR VGND VPWR VGND sky130_ef_sc_hd__decap_12
XTAP_TAPCELL_ROW_18_469 VGND VPWR sky130_fd_sc_hd__tapvpwrvgnd_1
XFILLER_31_411 VGND VGND VPWR VPWR sky130_fd_sc_hd__fill_1
XFILLER_71_591 VPWR VGND VPWR VGND sky130_ef_sc_hd__decap_12
XTAP_TAPCELL_ROW_100_1453 VGND VPWR sky130_fd_sc_hd__tapvpwrvgnd_1
X_4510_ _0271_ _0272_ _0219_ VGND VGND VPWR VPWR _0275_ sky130_fd_sc_hd__a21oi_1
X_5490_ _1279_ _1291_ VGND VGND VPWR VPWR _1292_ sky130_fd_sc_hd__xnor2_1
X_4441_ _0203_ _0204_ _0205_ VGND VGND VPWR VPWR _0207_ sky130_fd_sc_hd__nand3_1
XPHY_EDGE_ROW_9_Right_9 VGND VGND VPWR VPWR sky130_fd_sc_hd__decap_3
X_4372_ _0137_ _0139_ VGND VGND VPWR VPWR _0140_ sky130_fd_sc_hd__nand2b_1
X_6111_ _1822_ _1825_ VGND VGND VPWR VPWR _1969_ sky130_fd_sc_hd__nand2_1
XFILLER_98_444 VGND VGND VPWR VPWR sky130_fd_sc_hd__fill_1
XTAP_TAPCELL_ROW_111_1582 VGND VPWR sky130_fd_sc_hd__tapvpwrvgnd_1
XPHY_EDGE_ROW_107_Right_107 VGND VGND VPWR VPWR sky130_fd_sc_hd__decap_3
XFILLER_98_477 VPWR VGND VPWR VGND sky130_ef_sc_hd__decap_12
X_6042_ _1890_ _1891_ _1882_ VGND VGND VPWR VPWR _1893_ sky130_fd_sc_hd__a21o_1
XFILLER_79_691 VGND VGND VPWR VPWR sky130_fd_sc_hd__fill_1
XFILLER_66_363 VGND VGND VPWR VPWR sky130_fd_sc_hd__fill_1
XFILLER_54_525 VGND VGND VPWR VPWR sky130_fd_sc_hd__fill_1
XFILLER_26_216 VPWR VGND VPWR VGND sky130_ef_sc_hd__decap_12
XTAP_TAPCELL_ROW_37_701 VGND VPWR sky130_fd_sc_hd__tapvpwrvgnd_1
XFILLER_93_193 VGND VGND VPWR VPWR sky130_fd_sc_hd__decap_8
XFILLER_81_355 VPWR VGND VPWR VGND sky130_ef_sc_hd__decap_12
XFILLER_41_219 VGND VGND VPWR VPWR sky130_fd_sc_hd__decap_4
X_6875_ net180 _alu_i0.Datapath_i.fu_alu_33673_33851.out1\[1\] VGND VGND VPWR VPWR
+ _alu_i0.Datapath_i.reg_0.reg_out1\[1\] sky130_fd_sc_hd__dfxtp_1
XFILLER_22_411 VGND VGND VPWR VPWR sky130_fd_sc_hd__decap_8
XFILLER_22_433 VPWR VGND VPWR VGND sky130_ef_sc_hd__decap_12
X_5826_ net237 net223 net449 net446 VGND VGND VPWR VPWR _1658_ sky130_fd_sc_hd__and4_1
X_5757_ _1453_ _1459_ VGND VGND VPWR VPWR _1584_ sky130_fd_sc_hd__nor2_1
X_4708_ _0466_ _0467_ _0468_ VGND VGND VPWR VPWR _0470_ sky130_fd_sc_hd__nand3_1
X_5688_ _1504_ _1505_ _1501_ VGND VGND VPWR VPWR _1508_ sky130_fd_sc_hd__a21o_1
X_4639_ _0400_ _0401_ _0334_ _0337_ VGND VGND VPWR VPWR _0402_ sky130_fd_sc_hd__o211a_1
XFILLER_78_27 VGND VGND VPWR VPWR sky130_fd_sc_hd__fill_1
XFILLER_89_455 VPWR VGND VPWR VGND sky130_ef_sc_hd__decap_12
XFILLER_1_326 VGND VGND VPWR VPWR sky130_fd_sc_hd__decap_3
X_6309_ _2183_ _2184_ VGND VGND VPWR VPWR _2185_ sky130_fd_sc_hd__nor2_1
XFILLER_77_617 VPWR VGND VPWR VGND sky130_ef_sc_hd__decap_12
XFILLER_76_105 VGND VGND VPWR VPWR sky130_fd_sc_hd__decap_8
XFILLER_94_15 VPWR VGND VPWR VGND sky130_ef_sc_hd__decap_12
XFILLER_45_514 VGND VGND VPWR VPWR sky130_fd_sc_hd__decap_8
XFILLER_72_399 VPWR VGND VPWR VGND sky130_ef_sc_hd__decap_12
XFILLER_13_411 VGND VGND VPWR VPWR sky130_fd_sc_hd__fill_1
XFILLER_13_433 VPWR VGND VPWR VGND sky130_ef_sc_hd__decap_12
XTAP_TAPCELL_ROW_15_428 VGND VPWR sky130_fd_sc_hd__tapvpwrvgnd_1
XFILLER_25_293 VGND VGND VPWR VPWR sky130_fd_sc_hd__decap_6
XFILLER_13_488 VGND VGND VPWR VPWR sky130_fd_sc_hd__decap_4
XFILLER_40_274 VGND VGND VPWR VPWR sky130_fd_sc_hd__decap_8
XFILLER_5_665 VGND VGND VPWR VPWR sky130_fd_sc_hd__decap_6
XFILLER_4_153 VPWR VGND VPWR VGND sky130_ef_sc_hd__decap_12
XFILLER_4_197 VPWR VGND VPWR VGND sky130_ef_sc_hd__decap_12
XFILLER_95_458 VGND VGND VPWR VPWR sky130_fd_sc_hd__decap_8
XFILLER_95_425 VGND VGND VPWR VPWR sky130_fd_sc_hd__decap_3
XFILLER_68_82 VGND VGND VPWR VPWR sky130_fd_sc_hd__fill_2
XFILLER_82_108 VPWR VGND VPWR VGND sky130_ef_sc_hd__decap_12
XFILLER_91_653 VPWR VGND VPWR VGND sky130_ef_sc_hd__decap_12
XFILLER_90_141 VGND VGND VPWR VPWR sky130_fd_sc_hd__decap_4
XFILLER_84_81 VGND VGND VPWR VPWR sky130_fd_sc_hd__decap_3
X_4990_ _0629_ _0637_ _0636_ VGND VGND VPWR VPWR _0748_ sky130_fd_sc_hd__a21o_1
X_3941_ net136 _3113_ _3131_ net129 VGND VGND VPWR VPWR _3132_ sky130_fd_sc_hd__o211a_1
XFILLER_16_271 VPWR VGND VPWR VGND sky130_ef_sc_hd__decap_12
XFILLER_90_3 VPWR VGND VPWR VGND sky130_ef_sc_hd__decap_12
X_3872_ _2974_ _3065_ net160 VGND VGND VPWR VPWR _3066_ sky130_fd_sc_hd__mux2_1
X_6660_ net464 net336 _2393_ _2392_ VGND VGND VPWR VPWR _2568_ sky130_fd_sc_hd__a31o_1
X_5611_ _1293_ _1301_ _1300_ VGND VGND VPWR VPWR _1424_ sky130_fd_sc_hd__a21o_1
X_6591_ _2491_ _2492_ VGND VGND VPWR VPWR _2493_ sky130_fd_sc_hd__xnor2_1
X_5542_ _1223_ _1224_ _1221_ VGND VGND VPWR VPWR _1348_ sky130_fd_sc_hd__a21o_1
X_5473_ _1271_ _1272_ VGND VGND VPWR VPWR _1273_ sky130_fd_sc_hd__nor2_1
XTAP_TAPCELL_ROW_113_1611 VGND VPWR sky130_fd_sc_hd__tapvpwrvgnd_1
X_4424_ _0188_ _0189_ VGND VGND VPWR VPWR _0190_ sky130_fd_sc_hd__and2b_1
XFILLER_113_541 VPWR VGND VPWR VGND sky130_ef_sc_hd__decap_12
X_4355_ net225 net422 net414 net238 VGND VGND VPWR VPWR _0123_ sky130_fd_sc_hd__a22o_1
XPHY_EDGE_ROW_92_Left_209 VGND VGND VPWR VPWR sky130_fd_sc_hd__decap_3
Xfanout405 net27 VGND VGND VPWR VPWR net405 sky130_fd_sc_hd__clkbuf_4
Xfanout416 net418 VGND VGND VPWR VPWR net416 sky130_fd_sc_hd__buf_2
XFILLER_59_617 VPWR VGND VPWR VGND sky130_ef_sc_hd__decap_12
XFILLER_58_105 VPWR VGND VPWR VGND sky130_ef_sc_hd__decap_12
Xfanout427 net21 VGND VGND VPWR VPWR net427 sky130_fd_sc_hd__buf_2
XFILLER_48_19 VGND VGND VPWR VPWR sky130_fd_sc_hd__decap_8
Xfanout438 net439 VGND VGND VPWR VPWR net438 sky130_fd_sc_hd__buf_2
XFILLER_113_585 VPWR VGND VPWR VGND sky130_ef_sc_hd__decap_12
XFILLER_100_213 VGND VGND VPWR VPWR sky130_fd_sc_hd__fill_1
X_4286_ net471 net249 net238 net454 VGND VGND VPWR VPWR _0057_ sky130_fd_sc_hd__and4_1
XFILLER_58_138 VGND VGND VPWR VPWR sky130_fd_sc_hd__fill_2
Xfanout449 net13 VGND VGND VPWR VPWR net449 sky130_fd_sc_hd__buf_2
X_6025_ net468 net254 _1872_ VGND VGND VPWR VPWR _1874_ sky130_fd_sc_hd__a21o_1
XFILLER_73_119 VGND VGND VPWR VPWR sky130_fd_sc_hd__decap_8
XFILLER_66_171 VGND VGND VPWR VPWR sky130_fd_sc_hd__fill_1
XFILLER_27_536 VPWR VGND VPWR VGND sky130_ef_sc_hd__decap_12
XFILLER_64_29 VGND VGND VPWR VPWR sky130_fd_sc_hd__decap_6
XFILLER_54_377 VPWR VGND VPWR VGND sky130_ef_sc_hd__decap_12
XFILLER_35_580 VGND VGND VPWR VPWR sky130_fd_sc_hd__fill_2
X_6858_ _2749_ _2781_ VGND VGND VPWR VPWR _2785_ sky130_fd_sc_hd__xnor2_1
X_5809_ _1630_ _1638_ _1639_ VGND VGND VPWR VPWR _1640_ sky130_fd_sc_hd__nand3_1
XTAP_TAPCELL_ROW_40_729 VGND VPWR sky130_fd_sc_hd__tapvpwrvgnd_1
XFILLER_50_583 VGND VGND VPWR VPWR sky130_fd_sc_hd__decap_4
XFILLER_13_55 VGND VGND VPWR VPWR sky130_fd_sc_hd__fill_1
XFILLER_22_296 VPWR VGND VPWR VGND sky130_ef_sc_hd__decap_12
X_6789_ _2707_ _2708_ VGND VGND VPWR VPWR _2709_ sky130_fd_sc_hd__nor2_1
XFILLER_13_77 VGND VGND VPWR VPWR sky130_fd_sc_hd__fill_1
XTAP_TAPCELL_ROW_20_486 VGND VPWR sky130_fd_sc_hd__tapvpwrvgnd_1
XTAP_TAPCELL_ROW_20_497 VGND VPWR sky130_fd_sc_hd__tapvpwrvgnd_1
XTAP_TAPCELL_ROW_75_1149 VGND VPWR sky130_fd_sc_hd__tapvpwrvgnd_1
XFILLER_2_613 VPWR VGND VPWR VGND sky130_ef_sc_hd__decap_12
XFILLER_2_657 VPWR VGND VPWR VGND sky130_ef_sc_hd__decap_12
XFILLER_65_609 VGND VGND VPWR VPWR sky130_fd_sc_hd__fill_1
XFILLER_38_41 VPWR VGND VPWR VGND sky130_ef_sc_hd__decap_12
XFILLER_38_85 VGND VGND VPWR VPWR sky130_fd_sc_hd__decap_3
XTAP_TAPCELL_ROW_48_829 VGND VPWR sky130_fd_sc_hd__tapvpwrvgnd_1
XFILLER_57_182 VGND VGND VPWR VPWR sky130_fd_sc_hd__decap_8
XFILLER_45_344 VGND VGND VPWR VPWR sky130_fd_sc_hd__decap_4
XTAP_TAPCELL_ROW_86_1289 VGND VPWR sky130_fd_sc_hd__tapvpwrvgnd_1
XTAP_TAPCELL_ROW_86_1278 VGND VPWR sky130_fd_sc_hd__tapvpwrvgnd_1
XFILLER_72_141 VGND VGND VPWR VPWR sky130_fd_sc_hd__decap_8
XTAP_TAPCELL_ROW_28_586 VGND VPWR sky130_fd_sc_hd__tapvpwrvgnd_1
XFILLER_41_561 VGND VGND VPWR VPWR sky130_fd_sc_hd__decap_4
XFILLER_9_223 VGND VGND VPWR VPWR sky130_fd_sc_hd__fill_1
XFILLER_13_263 VGND VGND VPWR VPWR sky130_fd_sc_hd__fill_1
XFILLER_70_94 VGND VGND VPWR VPWR sky130_fd_sc_hd__fill_2
XFILLER_9_289 VGND VGND VPWR VPWR sky130_fd_sc_hd__fill_1
XFILLER_9_278 VGND VGND VPWR VPWR sky130_fd_sc_hd__fill_2
XFILLER_114_305 VGND VGND VPWR VPWR sky130_fd_sc_hd__decap_3
XFILLER_5_473 VGND VGND VPWR VPWR sky130_fd_sc_hd__decap_6
XFILLER_5_484 VPWR VGND VPWR VGND sky130_ef_sc_hd__decap_12
XFILLER_68_414 VGND VGND VPWR VPWR sky130_fd_sc_hd__fill_1
X_4140_ net438 _0994_ _3314_ VGND VGND VPWR VPWR _3322_ sky130_fd_sc_hd__and3_1
XFILLER_110_533 VPWR VGND VPWR VGND sky130_ef_sc_hd__decap_12
XFILLER_68_436 VPWR VGND VPWR VGND sky130_ef_sc_hd__decap_12
X_4071_ net140 _3254_ _3255_ VGND VGND VPWR VPWR _3256_ sky130_fd_sc_hd__or3b_1
XFILLER_48_193 VGND VGND VPWR VPWR sky130_fd_sc_hd__decap_3
XFILLER_91_472 VGND VGND VPWR VPWR sky130_fd_sc_hd__fill_2
XFILLER_36_377 VPWR VGND VPWR VGND sky130_ef_sc_hd__decap_12
X_4973_ _0729_ _0730_ VGND VGND VPWR VPWR _0731_ sky130_fd_sc_hd__or2_1
X_3924_ _3114_ VGND VGND VPWR VPWR _3115_ sky130_fd_sc_hd__inv_2
X_6712_ net436 net213 VGND VGND VPWR VPWR _2625_ sky130_fd_sc_hd__nand2_1
X_6643_ _2525_ _2548_ VGND VGND VPWR VPWR _2549_ sky130_fd_sc_hd__nor2_1
X_3855_ net261 net324 VGND VGND VPWR VPWR _3049_ sky130_fd_sc_hd__nand2_1
X_3786_ _2981_ _2982_ VGND VGND VPWR VPWR _2983_ sky130_fd_sc_hd__nor2_1
X_6574_ _2471_ _2472_ _2256_ _2258_ VGND VGND VPWR VPWR _2475_ sky130_fd_sc_hd__o211a_1
X_5525_ _1328_ _1329_ _1202_ _1204_ VGND VGND VPWR VPWR _1330_ sky130_fd_sc_hd__a211oi_1
X_5456_ _1188_ _1252_ _1253_ VGND VGND VPWR VPWR _1254_ sky130_fd_sc_hd__nor3_2
X_4407_ _0159_ _0173_ VGND VGND VPWR VPWR _0174_ sky130_fd_sc_hd__xnor2_1
XFILLER_105_349 VGND VGND VPWR VPWR sky130_fd_sc_hd__decap_8
Xfanout202 net204 VGND VGND VPWR VPWR net202 sky130_fd_sc_hd__clkbuf_4
XFILLER_99_561 VPWR VGND VPWR VGND sky130_ef_sc_hd__decap_12
Xfanout213 net60 VGND VGND VPWR VPWR net213 sky130_fd_sc_hd__buf_4
X_5387_ _1172_ _1178_ VGND VGND VPWR VPWR _1180_ sky130_fd_sc_hd__and2_1
XFILLER_113_393 VGND VGND VPWR VPWR sky130_fd_sc_hd__fill_2
XFILLER_101_500 VGND VGND VPWR VPWR sky130_fd_sc_hd__decap_4
X_4338_ _0104_ _0105_ VGND VGND VPWR VPWR _0107_ sky130_fd_sc_hd__xnor2_1
Xfanout224 net230 VGND VGND VPWR VPWR net224 sky130_fd_sc_hd__buf_2
Xfanout246 net248 VGND VGND VPWR VPWR net246 sky130_fd_sc_hd__clkbuf_4
XFILLER_59_447 VGND VGND VPWR VPWR sky130_fd_sc_hd__fill_1
Xfanout235 net237 VGND VGND VPWR VPWR net235 sky130_fd_sc_hd__buf_2
XFILLER_115_57 VPWR VGND VPWR VGND sky130_ef_sc_hd__decap_12
Xfanout279 net280 VGND VGND VPWR VPWR net279 sky130_fd_sc_hd__buf_2
X_4269_ net152 net117 _2933_ _0043_ VGND VGND VPWR VPWR _0044_ sky130_fd_sc_hd__a31o_1
XFILLER_59_469 VGND VGND VPWR VPWR sky130_fd_sc_hd__decap_3
Xfanout268 net270 VGND VGND VPWR VPWR net268 sky130_fd_sc_hd__clkbuf_4
Xfanout257 net50 VGND VGND VPWR VPWR net257 sky130_fd_sc_hd__buf_2
XFILLER_86_288 VGND VGND VPWR VPWR sky130_fd_sc_hd__decap_6
XFILLER_74_428 VGND VGND VPWR VPWR sky130_fd_sc_hd__decap_4
X_6008_ _1853_ _1854_ _1671_ _1673_ VGND VGND VPWR VPWR _1857_ sky130_fd_sc_hd__o211a_1
XFILLER_55_653 VPWR VGND VPWR VGND sky130_ef_sc_hd__decap_12
XFILLER_82_450 VGND VGND VPWR VPWR sky130_fd_sc_hd__decap_6
XFILLER_70_612 VGND VGND VPWR VPWR sky130_fd_sc_hd__fill_1
XFILLER_54_141 VPWR VGND VPWR VGND sky130_ef_sc_hd__decap_12
XFILLER_70_645 VPWR VGND VPWR VGND sky130_ef_sc_hd__decap_12
XFILLER_70_623 VPWR VGND VPWR VGND sky130_ef_sc_hd__decap_12
XFILLER_54_185 VGND VGND VPWR VPWR sky130_fd_sc_hd__decap_8
XFILLER_70_689 VGND VGND VPWR VPWR sky130_fd_sc_hd__decap_3
XTAP_TAPCELL_ROW_25_556 VGND VPWR sky130_fd_sc_hd__tapvpwrvgnd_1
XTAP_TAPCELL_ROW_53_887 VGND VPWR sky130_fd_sc_hd__tapvpwrvgnd_1
XFILLER_108_154 VGND VGND VPWR VPWR sky130_fd_sc_hd__fill_1
XFILLER_40_64 VGND VGND VPWR VPWR sky130_fd_sc_hd__fill_1
XFILLER_104_360 VGND VGND VPWR VPWR sky130_fd_sc_hd__decap_4
XTAP_TAPCELL_ROW_88_1307 VGND VPWR sky130_fd_sc_hd__tapvpwrvgnd_1
XFILLER_77_277 VGND VGND VPWR VPWR sky130_fd_sc_hd__decap_3
XFILLER_1_69 VPWR VGND VPWR VGND sky130_ef_sc_hd__decap_12
XFILLER_18_333 VGND VGND VPWR VPWR sky130_fd_sc_hd__decap_8
XFILLER_73_461 VPWR VGND VPWR VGND sky130_ef_sc_hd__decap_12
XFILLER_61_601 VPWR VGND VPWR VGND sky130_ef_sc_hd__decap_12
XFILLER_60_122 VGND VGND VPWR VPWR sky130_fd_sc_hd__decap_8
XTAP_TAPCELL_ROW_99_1436 VGND VPWR sky130_fd_sc_hd__tapvpwrvgnd_1
X_3640_ net226 net406 VGND VGND VPWR VPWR _2843_ sky130_fd_sc_hd__nor2_1
X_3571_ net431 net386 net312 net260 net356 net289 VGND VGND VPWR VPWR _2575_ sky130_fd_sc_hd__mux4_1
X_5310_ _1094_ _1095_ VGND VGND VPWR VPWR _1096_ sky130_fd_sc_hd__nand2b_1
X_6290_ _2162_ _2163_ _2001_ _2003_ VGND VGND VPWR VPWR _2165_ sky130_fd_sc_hd__o211a_1
XFILLER_5_281 VGND VGND VPWR VPWR sky130_fd_sc_hd__decap_8
XFILLER_114_168 VGND VGND VPWR VPWR sky130_fd_sc_hd__decap_3
X_5241_ net221 net60 _1017_ _1018_ VGND VGND VPWR VPWR _1020_ sky130_fd_sc_hd__nand4_2
XFILLER_96_520 VGND VGND VPWR VPWR sky130_fd_sc_hd__fill_2
X_5172_ _0941_ _0944_ VGND VGND VPWR VPWR _0945_ sky130_fd_sc_hd__xnor2_1
X_4123_ net439 net441 net444 net447 net347 net279 VGND VGND VPWR VPWR _3306_ sky130_fd_sc_hd__mux4_1
XFILLER_110_352 VPWR VGND VPWR VGND sky130_ef_sc_hd__decap_12
X_4054_ _3239_ _3192_ net281 VGND VGND VPWR VPWR _3240_ sky130_fd_sc_hd__mux2_1
Xinput2 a[10] VGND VGND VPWR VPWR net2 sky130_fd_sc_hd__clkbuf_4
XFILLER_83_225 VPWR VGND VPWR VGND sky130_ef_sc_hd__decap_12
XTAP_TAPCELL_ROW_108_1543 VGND VPWR sky130_fd_sc_hd__tapvpwrvgnd_1
XFILLER_71_409 VGND VGND VPWR VPWR sky130_fd_sc_hd__fill_1
XFILLER_64_450 VGND VGND VPWR VPWR sky130_fd_sc_hd__fill_1
XFILLER_52_601 VGND VGND VPWR VPWR sky130_fd_sc_hd__decap_6
XFILLER_36_141 VGND VGND VPWR VPWR sky130_fd_sc_hd__decap_3
XFILLER_37_653 VPWR VGND VPWR VGND sky130_ef_sc_hd__decap_12
XFILLER_101_15 VPWR VGND VPWR VGND sky130_ef_sc_hd__decap_12
XFILLER_52_645 VPWR VGND VPWR VGND sky130_ef_sc_hd__decap_12
X_4956_ _0712_ _0713_ VGND VGND VPWR VPWR _0714_ sky130_fd_sc_hd__and2b_1
XFILLER_61_19 VPWR VGND VPWR VGND sky130_ef_sc_hd__decap_12
XFILLER_52_689 VGND VGND VPWR VPWR sky130_fd_sc_hd__decap_3
XTAP_TAPCELL_ROW_22_515 VGND VPWR sky130_fd_sc_hd__tapvpwrvgnd_1
X_4887_ _0563_ _0571_ _0570_ VGND VGND VPWR VPWR _0646_ sky130_fd_sc_hd__o21ba_1
X_3907_ net123 _3098_ _3093_ _1887_ VGND VGND VPWR VPWR _3099_ sky130_fd_sc_hd__o2bb2a_1
XTAP_TAPCELL_ROW_50_846 VGND VPWR sky130_fd_sc_hd__tapvpwrvgnd_1
XTAP_TAPCELL_ROW_50_857 VGND VPWR sky130_fd_sc_hd__tapvpwrvgnd_1
X_3838_ _2983_ _2988_ _2989_ _3007_ _3032_ VGND VGND VPWR VPWR _3033_ sky130_fd_sc_hd__o311a_1
X_6626_ net258 net301 VGND VGND VPWR VPWR _2530_ sky130_fd_sc_hd__nand2_1
X_6557_ _2454_ _2455_ VGND VGND VPWR VPWR _2457_ sky130_fd_sc_hd__xnor2_1
XFILLER_106_625 VPWR VGND VPWR VGND sky130_ef_sc_hd__decap_12
X_5508_ _1307_ _1308_ _1184_ _1186_ VGND VGND VPWR VPWR _1312_ sky130_fd_sc_hd__a211o_1
X_3769_ net369 _0928_ VGND VGND VPWR VPWR _2967_ sky130_fd_sc_hd__nand2_1
XFILLER_105_113 VGND VGND VPWR VPWR sky130_fd_sc_hd__decap_4
X_6488_ _2376_ _2378_ _2358_ VGND VGND VPWR VPWR _2381_ sky130_fd_sc_hd__o21ai_1
XFILLER_106_669 VPWR VGND VPWR VGND sky130_ef_sc_hd__decap_12
XTAP_TAPCELL_ROW_72_1119 VGND VPWR sky130_fd_sc_hd__tapvpwrvgnd_1
X_5439_ net219 net175 net206 net199 VGND VGND VPWR VPWR _1236_ sky130_fd_sc_hd__nand4_2
XFILLER_87_531 VGND VGND VPWR VPWR sky130_fd_sc_hd__decap_6
XFILLER_86_27 VGND VGND VPWR VPWR sky130_fd_sc_hd__fill_1
XFILLER_47_417 VPWR VGND VPWR VGND sky130_ef_sc_hd__decap_12
XFILLER_101_385 VGND VGND VPWR VPWR sky130_fd_sc_hd__decap_6
XTAP_TAPCELL_ROW_58_946 VGND VPWR sky130_fd_sc_hd__tapvpwrvgnd_1
XFILLER_19_87 VPWR VGND VPWR VGND sky130_ef_sc_hd__decap_12
XFILLER_62_409 VGND VGND VPWR VPWR sky130_fd_sc_hd__fill_1
XFILLER_55_461 VPWR VGND VPWR VGND sky130_ef_sc_hd__decap_12
XTAP_TAPCELL_ROW_2_273 VGND VPWR sky130_fd_sc_hd__tapvpwrvgnd_1
XTAP_TAPCELL_ROW_83_1248 VGND VPWR sky130_fd_sc_hd__tapvpwrvgnd_1
XFILLER_27_196 VPWR VGND VPWR VGND sky130_ef_sc_hd__decap_12
XFILLER_42_133 VGND VGND VPWR VPWR sky130_fd_sc_hd__fill_2
XFILLER_70_475 VGND VGND VPWR VPWR sky130_fd_sc_hd__fill_1
XFILLER_42_166 VGND VGND VPWR VPWR sky130_fd_sc_hd__fill_1
XFILLER_23_380 VPWR VGND VPWR VGND sky130_ef_sc_hd__decap_12
XFILLER_11_553 VGND VGND VPWR VPWR sky130_fd_sc_hd__decap_6
XFILLER_11_597 VPWR VGND VPWR VGND sky130_ef_sc_hd__decap_12
XFILLER_51_85 VGND VGND VPWR VPWR sky130_fd_sc_hd__decap_4
XTAP_TAPCELL_ROW_94_1377 VGND VPWR sky130_fd_sc_hd__tapvpwrvgnd_1
XFILLER_111_105 VGND VGND VPWR VPWR sky130_fd_sc_hd__decap_6
XFILLER_105_691 VGND VGND VPWR VPWR sky130_fd_sc_hd__fill_1
XFILLER_78_531 VGND VGND VPWR VPWR sky130_fd_sc_hd__fill_1
XFILLER_76_93 VPWR VGND VPWR VGND sky130_ef_sc_hd__decap_12
XFILLER_65_225 VPWR VGND VPWR VGND sky130_ef_sc_hd__decap_12
XFILLER_38_439 VPWR VGND VPWR VGND sky130_ef_sc_hd__decap_12
XFILLER_80_206 VGND VGND VPWR VPWR sky130_fd_sc_hd__decap_4
XFILLER_18_141 VGND VGND VPWR VPWR sky130_fd_sc_hd__decap_4
XFILLER_19_653 VPWR VGND VPWR VGND sky130_ef_sc_hd__decap_12
XFILLER_34_601 VPWR VGND VPWR VGND sky130_ef_sc_hd__decap_12
XFILLER_33_111 VGND VGND VPWR VPWR sky130_fd_sc_hd__fill_1
X_4810_ _0567_ _0568_ _0569_ VGND VGND VPWR VPWR _0570_ sky130_fd_sc_hd__and3_1
XFILLER_73_291 VPWR VGND VPWR VGND sky130_ef_sc_hd__decap_12
XFILLER_34_645 VPWR VGND VPWR VGND sky130_ef_sc_hd__decap_12
XFILLER_21_317 VGND VGND VPWR VPWR sky130_fd_sc_hd__decap_4
X_5790_ _1617_ _1618_ VGND VGND VPWR VPWR _1619_ sky130_fd_sc_hd__xnor2_1
XFILLER_34_689 VGND VGND VPWR VPWR sky130_fd_sc_hd__decap_3
XTAP_TAPCELL_ROW_103_1484 VGND VPWR sky130_fd_sc_hd__tapvpwrvgnd_1
X_4741_ _0489_ _0500_ VGND VGND VPWR VPWR _0502_ sky130_fd_sc_hd__xnor2_1
X_4672_ _2281_ _0432_ VGND VGND VPWR VPWR _0434_ sky130_fd_sc_hd__xnor2_1
X_3623_ net231 _2821_ _2826_ VGND VGND VPWR VPWR _2827_ sky130_fd_sc_hd__o21ai_1
X_6411_ _2080_ _2082_ _2294_ VGND VGND VPWR VPWR _2297_ sky130_fd_sc_hd__nor3_1
X_3554_ net354 net406 VGND VGND VPWR VPWR _2390_ sky130_fd_sc_hd__nand2_1
X_6342_ _2218_ _2219_ _2197_ VGND VGND VPWR VPWR _2221_ sky130_fd_sc_hd__o21a_1
XFILLER_103_617 VPWR VGND VPWR VGND sky130_ef_sc_hd__decap_12
X_3485_ net371 net364 net431 net385 net351 net289 VGND VGND VPWR VPWR _1637_ sky130_fd_sc_hd__mux4_1
X_6273_ _1982_ _1984_ _2144_ _2145_ VGND VGND VPWR VPWR _2146_ sky130_fd_sc_hd__a211o_1
X_5224_ net224 net176 net170 net236 VGND VGND VPWR VPWR _1001_ sky130_fd_sc_hd__a22o_1
X_5155_ _0923_ _0924_ _0860_ _0862_ VGND VGND VPWR VPWR _0926_ sky130_fd_sc_hd__a211o_1
XFILLER_69_586 VGND VGND VPWR VPWR sky130_fd_sc_hd__decap_8
XFILLER_56_203 VGND VGND VPWR VPWR sky130_fd_sc_hd__fill_1
XFILLER_56_19 VGND VGND VPWR VPWR sky130_fd_sc_hd__decap_8
X_5086_ net434 net387 net210 net202 VGND VGND VPWR VPWR _0851_ sky130_fd_sc_hd__nand4_2
XFILLER_56_225 VPWR VGND VPWR VGND sky130_ef_sc_hd__decap_12
XFILLER_29_439 VGND VGND VPWR VPWR sky130_fd_sc_hd__fill_1
X_4106_ _3247_ _3269_ _3287_ _3288_ VGND VGND VPWR VPWR _3289_ sky130_fd_sc_hd__a31o_1
X_4037_ _3218_ _3222_ _3223_ _2860_ net118 VGND VGND VPWR VPWR _alu_i0.Datapath_i.fu_alu_33673_33851.out1\[20\]
+ sky130_fd_sc_hd__a32o_1
XTAP_TAPCELL_ROW_55_916 VGND VPWR sky130_fd_sc_hd__tapvpwrvgnd_1
XFILLER_37_461 VGND VGND VPWR VPWR sky130_fd_sc_hd__fill_2
XTAP_TAPCELL_ROW_69_1081 VGND VPWR sky130_fd_sc_hd__tapvpwrvgnd_1
XFILLER_64_280 VGND VGND VPWR VPWR sky130_fd_sc_hd__decap_8
XFILLER_37_494 VGND VGND VPWR VPWR sky130_fd_sc_hd__decap_8
XFILLER_72_29 VPWR VGND VPWR VGND sky130_ef_sc_hd__decap_12
XFILLER_52_475 VGND VGND VPWR VPWR sky130_fd_sc_hd__fill_1
X_5988_ _1689_ _1691_ _1833_ _1834_ VGND VGND VPWR VPWR _1835_ sky130_fd_sc_hd__a211o_1
XTAP_TAPCELL_ROW_35_673 VGND VPWR sky130_fd_sc_hd__tapvpwrvgnd_1
X_4939_ _0696_ _0697_ VGND VGND VPWR VPWR _0698_ sky130_fd_sc_hd__xnor2_1
XANTENNA_40 net418 VGND VGND VPWR VPWR sky130_fd_sc_hd__diode_2
X_6609_ net390 net256 VGND VGND VPWR VPWR _2512_ sky130_fd_sc_hd__nand2_1
XFILLER_20_394 VGND VGND VPWR VPWR sky130_fd_sc_hd__decap_4
XFILLER_21_55 VGND VGND VPWR VPWR sky130_fd_sc_hd__fill_1
XFILLER_97_15 VPWR VGND VPWR VGND sky130_ef_sc_hd__decap_12
XFILLER_106_499 VPWR VGND VPWR VGND sky130_ef_sc_hd__decap_12
XFILLER_106_477 VGND VGND VPWR VPWR sky130_fd_sc_hd__decap_6
XTAP_TAPCELL_ROW_7_332 VGND VPWR sky130_fd_sc_hd__tapvpwrvgnd_1
XFILLER_87_361 VPWR VGND VPWR VGND sky130_ef_sc_hd__decap_12
XFILLER_75_545 VPWR VGND VPWR VGND sky130_ef_sc_hd__decap_12
XFILLER_47_236 VGND VGND VPWR VPWR sky130_fd_sc_hd__fill_1
XFILLER_101_193 VGND VGND VPWR VPWR sky130_fd_sc_hd__fill_1
XFILLER_75_589 VGND VGND VPWR VPWR sky130_fd_sc_hd__fill_1
XFILLER_16_601 VPWR VGND VPWR VGND sky130_ef_sc_hd__decap_12
XFILLER_46_74 VGND VGND VPWR VPWR sky130_fd_sc_hd__decap_8
XFILLER_46_85 VGND VGND VPWR VPWR sky130_fd_sc_hd__decap_8
XFILLER_16_645 VPWR VGND VPWR VGND sky130_ef_sc_hd__decap_12
XFILLER_70_272 VGND VGND VPWR VPWR sky130_fd_sc_hd__decap_6
XFILLER_15_199 VPWR VGND VPWR VGND sky130_ef_sc_hd__decap_12
XFILLER_30_125 VGND VGND VPWR VPWR sky130_fd_sc_hd__fill_1
XFILLER_30_169 VGND VGND VPWR VPWR sky130_fd_sc_hd__decap_8
XTAP_TAPCELL_ROW_96_1406 VGND VPWR sky130_fd_sc_hd__tapvpwrvgnd_1
XFILLER_7_321 VPWR VGND VPWR VGND sky130_ef_sc_hd__decap_12
XFILLER_7_57 VPWR VGND VPWR VGND sky130_ef_sc_hd__decap_12
XFILLER_109_293 VPWR VGND VPWR VGND sky130_ef_sc_hd__decap_12
XFILLER_98_637 VGND VGND VPWR VPWR sky130_fd_sc_hd__decap_6
XFILLER_97_125 VPWR VGND VPWR VGND sky130_ef_sc_hd__decap_12
XFILLER_112_469 VGND VGND VPWR VPWR sky130_fd_sc_hd__decap_6
XFILLER_97_169 VGND VGND VPWR VPWR sky130_fd_sc_hd__decap_8
XFILLER_16_3 VPWR VGND VPWR VGND sky130_ef_sc_hd__decap_12
XFILLER_66_589 VGND VGND VPWR VPWR sky130_fd_sc_hd__fill_2
XTAP_TAPCELL_ROW_105_1513 VGND VPWR sky130_fd_sc_hd__tapvpwrvgnd_1
X_5911_ _1744_ _1750_ VGND VGND VPWR VPWR _1751_ sky130_fd_sc_hd__xnor2_1
XFILLER_19_461 VPWR VGND VPWR VGND sky130_ef_sc_hd__decap_12
XFILLER_53_239 VGND VGND VPWR VPWR sky130_fd_sc_hd__decap_8
X_6891_ net181 _alu_i0.Datapath_i.fu_alu_33673_33851.out1\[17\] VGND VGND VPWR VPWR
+ _alu_i0.Datapath_i.reg_0.reg_out1\[17\] sky130_fd_sc_hd__dfxtp_1
XFILLER_81_559 VGND VGND VPWR VPWR sky130_fd_sc_hd__fill_1
XFILLER_34_431 VGND VGND VPWR VPWR sky130_fd_sc_hd__decap_4
XFILLER_46_291 VPWR VGND VPWR VGND sky130_ef_sc_hd__decap_12
X_5842_ _1546_ _1548_ VGND VGND VPWR VPWR _1676_ sky130_fd_sc_hd__nand2_1
XFILLER_34_475 VGND VGND VPWR VPWR sky130_fd_sc_hd__fill_1
X_5773_ net388 net299 net294 net395 VGND VGND VPWR VPWR _1600_ sky130_fd_sc_hd__a22o_1
XFILLER_22_637 VGND VGND VPWR VPWR sky130_fd_sc_hd__decap_6
XTAP_TAPCELL_ROW_32_632 VGND VPWR sky130_fd_sc_hd__tapvpwrvgnd_1
X_4724_ _0415_ _0483_ _0484_ VGND VGND VPWR VPWR _0485_ sky130_fd_sc_hd__and3_1
XTAP_TAPCELL_ROW_60_974 VGND VPWR sky130_fd_sc_hd__tapvpwrvgnd_1
XFILLER_21_169 VPWR VGND VPWR VGND sky130_ef_sc_hd__decap_12
XFILLER_30_681 VGND VGND VPWR VPWR sky130_fd_sc_hd__decap_8
X_4655_ _0412_ _0416_ VGND VGND VPWR VPWR _0417_ sky130_fd_sc_hd__and2_1
Xinput60 b[5] VGND VGND VPWR VPWR net60 sky130_fd_sc_hd__clkbuf_2
XTAP_TAPCELL_ROW_116_1642 VGND VPWR sky130_fd_sc_hd__tapvpwrvgnd_1
X_4586_ net474 net338 _0348_ VGND VGND VPWR VPWR _0349_ sky130_fd_sc_hd__and3_1
X_3606_ _2739_ _2794_ _2717_ VGND VGND VPWR VPWR _2810_ sky130_fd_sc_hd__a21o_1
Xinput71 opcode[5] VGND VGND VPWR VPWR net71 sky130_fd_sc_hd__clkbuf_1
XTAP_TAPCELL_ROW_116_1653 VGND VPWR sky130_fd_sc_hd__tapvpwrvgnd_1
X_3537_ net280 net25 VGND VGND VPWR VPWR _2204_ sky130_fd_sc_hd__nand2_1
X_6325_ _2200_ _2201_ VGND VGND VPWR VPWR _2202_ sky130_fd_sc_hd__xnor2_1
XFILLER_89_615 VGND VGND VPWR VPWR sky130_fd_sc_hd__fill_1
XFILLER_88_114 VGND VGND VPWR VPWR sky130_fd_sc_hd__decap_4
XFILLER_107_69 VGND VGND VPWR VPWR sky130_fd_sc_hd__decap_4
XFILLER_103_447 VGND VGND VPWR VPWR sky130_fd_sc_hd__fill_1
X_3468_ _1419_ _1441_ net282 VGND VGND VPWR VPWR _1452_ sky130_fd_sc_hd__mux2_1
X_6256_ _1430_ _2126_ VGND VGND VPWR VPWR _2127_ sky130_fd_sc_hd__xor2_1
X_5207_ _0869_ _0871_ _0979_ _0981_ VGND VGND VPWR VPWR _0984_ sky130_fd_sc_hd__a211o_1
XFILLER_76_309 VPWR VGND VPWR VGND sky130_ef_sc_hd__decap_12
XTAP_TAPCELL_ROW_4_302 VGND VPWR sky130_fd_sc_hd__tapvpwrvgnd_1
X_6187_ _2046_ _2048_ net376 net274 VGND VGND VPWR VPWR _2052_ sky130_fd_sc_hd__a2bb2o_1
X_5138_ _0799_ _0807_ _0806_ VGND VGND VPWR VPWR _0908_ sky130_fd_sc_hd__a21o_1
XFILLER_29_225 VGND VGND VPWR VPWR sky130_fd_sc_hd__decap_6
XFILLER_29_247 VGND VGND VPWR VPWR sky130_fd_sc_hd__decap_8
XFILLER_83_39 VPWR VGND VPWR VGND sky130_ef_sc_hd__decap_12
X_5069_ net252 net177 VGND VGND VPWR VPWR _0833_ sky130_fd_sc_hd__and2_1
XTAP_TAPCELL_ROW_80_1207 VGND VPWR sky130_fd_sc_hd__tapvpwrvgnd_1
XFILLER_13_615 VGND VGND VPWR VPWR sky130_fd_sc_hd__fill_1
XFILLER_25_453 VGND VGND VPWR VPWR sky130_fd_sc_hd__decap_4
XFILLER_25_464 VGND VGND VPWR VPWR sky130_fd_sc_hd__decap_4
XFILLER_32_65 VPWR VGND VPWR VGND sky130_ef_sc_hd__decap_12
XPHY_EDGE_ROW_112_Left_229 VGND VGND VPWR VPWR sky130_fd_sc_hd__decap_3
XTAP_TAPCELL_ROW_91_1347 VGND VPWR sky130_fd_sc_hd__tapvpwrvgnd_1
XFILLER_95_629 VPWR VGND VPWR VGND sky130_ef_sc_hd__decap_12
XFILLER_48_501 VPWR VGND VPWR VGND sky130_ef_sc_hd__decap_12
XFILLER_88_681 VGND VGND VPWR VPWR sky130_fd_sc_hd__decap_8
XFILLER_0_585 VGND VGND VPWR VPWR sky130_fd_sc_hd__decap_3
XFILLER_63_515 VGND VGND VPWR VPWR sky130_fd_sc_hd__fill_1
XFILLER_48_589 VPWR VGND VPWR VGND sky130_ef_sc_hd__decap_12
XFILLER_90_345 VGND VGND VPWR VPWR sky130_fd_sc_hd__decap_8
XFILLER_90_389 VPWR VGND VPWR VGND sky130_ef_sc_hd__decap_12
XFILLER_16_453 VGND VGND VPWR VPWR sky130_fd_sc_hd__decap_3
XFILLER_73_94 VGND VGND VPWR VPWR sky130_fd_sc_hd__fill_2
XFILLER_31_445 VGND VGND VPWR VPWR sky130_fd_sc_hd__decap_3
XTAP_TAPCELL_ROW_100_1454 VGND VPWR sky130_fd_sc_hd__tapvpwrvgnd_1
XFILLER_12_681 VGND VGND VPWR VPWR sky130_fd_sc_hd__decap_8
XFILLER_7_140 VGND VGND VPWR VPWR sky130_fd_sc_hd__fill_2
X_4440_ _0203_ _0204_ _0205_ VGND VGND VPWR VPWR _0206_ sky130_fd_sc_hd__and3_1
X_4371_ _0135_ _0136_ _0121_ VGND VGND VPWR VPWR _0139_ sky130_fd_sc_hd__a21o_1
X_6110_ _1766_ _1767_ _1770_ _1771_ _1763_ VGND VGND VPWR VPWR _1968_ sky130_fd_sc_hd__a32o_1
XFILLER_100_406 VPWR VGND VPWR VGND sky130_ef_sc_hd__decap_12
XFILLER_98_489 VPWR VGND VPWR VGND sky130_ef_sc_hd__decap_12
XFILLER_58_309 VPWR VGND VPWR VGND sky130_ef_sc_hd__decap_12
X_6041_ _1882_ _1890_ _1891_ VGND VGND VPWR VPWR _1892_ sky130_fd_sc_hd__nand3_1
XTAP_TAPCELL_ROW_111_1583 VGND VPWR sky130_fd_sc_hd__tapvpwrvgnd_1
XFILLER_39_545 VGND VGND VPWR VPWR sky130_fd_sc_hd__fill_1
XFILLER_93_161 VGND VGND VPWR VPWR sky130_fd_sc_hd__decap_6
XFILLER_81_312 VGND VGND VPWR VPWR sky130_fd_sc_hd__fill_1
XFILLER_26_228 VPWR VGND VPWR VGND sky130_ef_sc_hd__decap_12
XFILLER_81_334 VGND VGND VPWR VPWR sky130_fd_sc_hd__fill_2
XFILLER_81_367 VGND VGND VPWR VPWR sky130_fd_sc_hd__decap_6
X_6874_ net180 _alu_i0.Datapath_i.fu_alu_33673_33851.out1\[0\] VGND VGND VPWR VPWR
+ _alu_i0.Datapath_i.reg_0.reg_out1\[0\] sky130_fd_sc_hd__dfxtp_1
XTAP_TAPCELL_ROW_66_1040 VGND VPWR sky130_fd_sc_hd__tapvpwrvgnd_1
X_5825_ _1654_ _1655_ _1523_ VGND VGND VPWR VPWR _1657_ sky130_fd_sc_hd__a21oi_1
XTAP_TAPCELL_ROW_45_790 VGND VPWR sky130_fd_sc_hd__tapvpwrvgnd_1
XFILLER_22_445 VPWR VGND VPWR VGND sky130_ef_sc_hd__decap_12
X_5756_ _1580_ _1581_ VGND VGND VPWR VPWR _1582_ sky130_fd_sc_hd__and2b_1
X_4707_ _0466_ _0467_ _0468_ VGND VGND VPWR VPWR _0469_ sky130_fd_sc_hd__and3_1
X_5687_ _1501_ _1504_ _1505_ VGND VGND VPWR VPWR _1507_ sky130_fd_sc_hd__nand3_1
X_4638_ _0398_ _0399_ _0308_ _0311_ VGND VGND VPWR VPWR _0401_ sky130_fd_sc_hd__o211a_1
XFILLER_116_550 VGND VGND VPWR VPWR sky130_fd_sc_hd__fill_1
X_4569_ _0217_ _0220_ _0273_ VGND VGND VPWR VPWR _0333_ sky130_fd_sc_hd__a21oi_1
XTAP_TAPCELL_ROW_77_1180 VGND VPWR sky130_fd_sc_hd__tapvpwrvgnd_1
X_6308_ net405 net263 net256 net413 VGND VGND VPWR VPWR _2184_ sky130_fd_sc_hd__a22oi_1
XFILLER_89_467 VPWR VGND VPWR VGND sky130_ef_sc_hd__decap_12
XFILLER_77_629 VPWR VGND VPWR VGND sky130_ef_sc_hd__decap_12
X_6239_ _2065_ _2067_ _2105_ _2107_ VGND VGND VPWR VPWR _2109_ sky130_fd_sc_hd__o22ai_2
XFILLER_94_27 VGND VGND VPWR VPWR sky130_fd_sc_hd__fill_1
XFILLER_85_673 VPWR VGND VPWR VGND sky130_ef_sc_hd__decap_12
XFILLER_84_194 VGND VGND VPWR VPWR sky130_fd_sc_hd__fill_2
XFILLER_45_559 VGND VGND VPWR VPWR sky130_fd_sc_hd__fill_1
XFILLER_32_209 VGND VGND VPWR VPWR sky130_fd_sc_hd__fill_1
XTAP_TAPCELL_ROW_15_429 VGND VPWR sky130_fd_sc_hd__tapvpwrvgnd_1
XFILLER_43_31 VPWR VGND VPWR VGND sky130_ef_sc_hd__decap_12
XFILLER_9_405 VGND VGND VPWR VPWR sky130_fd_sc_hd__fill_1
XFILLER_13_445 VGND VGND VPWR VPWR sky130_fd_sc_hd__decap_3
XFILLER_9_449 VPWR VGND VPWR VGND sky130_ef_sc_hd__decap_12
XFILLER_40_264 VGND VGND VPWR VPWR sky130_fd_sc_hd__fill_1
XFILLER_107_561 VPWR VGND VPWR VGND sky130_ef_sc_hd__decap_12
XFILLER_107_550 VGND VGND VPWR VPWR sky130_fd_sc_hd__decap_8
XFILLER_4_165 VPWR VGND VPWR VGND sky130_ef_sc_hd__decap_12
XFILLER_68_94 VGND VGND VPWR VPWR sky130_fd_sc_hd__fill_1
XFILLER_0_382 VGND VGND VPWR VPWR sky130_fd_sc_hd__decap_8
XFILLER_0_393 VGND VGND VPWR VPWR sky130_fd_sc_hd__decap_3
XFILLER_36_504 VPWR VGND VPWR VGND sky130_ef_sc_hd__decap_12
XFILLER_91_665 VGND VGND VPWR VPWR sky130_fd_sc_hd__decap_6
X_3940_ _3129_ _3130_ _3112_ _3123_ VGND VGND VPWR VPWR _3131_ sky130_fd_sc_hd__a211o_1
XFILLER_90_197 VPWR VGND VPWR VGND sky130_ef_sc_hd__decap_12
XFILLER_16_283 VGND VGND VPWR VPWR sky130_fd_sc_hd__fill_1
X_3871_ _3064_ _3017_ net284 VGND VGND VPWR VPWR _3065_ sky130_fd_sc_hd__mux2_1
XFILLER_31_220 VGND VGND VPWR VPWR sky130_fd_sc_hd__decap_4
XFILLER_83_3 VPWR VGND VPWR VGND sky130_ef_sc_hd__decap_12
X_5610_ _1413_ _1420_ _1421_ VGND VGND VPWR VPWR _1423_ sky130_fd_sc_hd__nand3_1
X_6590_ _2327_ _2332_ _2326_ VGND VGND VPWR VPWR _2492_ sky130_fd_sc_hd__a21bo_1
XTAP_TAPCELL_ROW_42_760 VGND VPWR sky130_fd_sc_hd__tapvpwrvgnd_1
X_5541_ _1345_ _1346_ VGND VGND VPWR VPWR _1347_ sky130_fd_sc_hd__xnor2_1
X_5472_ _1151_ _1270_ VGND VGND VPWR VPWR _1272_ sky130_fd_sc_hd__and2_1
X_4423_ net426 net208 net201 net455 VGND VGND VPWR VPWR _0189_ sky130_fd_sc_hd__a22o_1
XTAP_TAPCELL_ROW_113_1612 VGND VPWR sky130_fd_sc_hd__tapvpwrvgnd_1
X_4354_ net249 net406 VGND VGND VPWR VPWR _0122_ sky130_fd_sc_hd__and2_1
Xfanout417 net418 VGND VGND VPWR VPWR net417 sky130_fd_sc_hd__clkbuf_4
XFILLER_113_553 VGND VGND VPWR VPWR sky130_fd_sc_hd__decap_6
XFILLER_98_253 VPWR VGND VPWR VGND sky130_ef_sc_hd__decap_12
Xfanout406 net408 VGND VGND VPWR VPWR net406 sky130_fd_sc_hd__buf_2
XFILLER_86_404 VGND VGND VPWR VPWR sky130_fd_sc_hd__fill_1
XFILLER_59_629 VPWR VGND VPWR VGND sky130_ef_sc_hd__decap_12
Xfanout428 net20 VGND VGND VPWR VPWR net428 sky130_fd_sc_hd__clkbuf_4
Xfanout439 net17 VGND VGND VPWR VPWR net439 sky130_fd_sc_hd__clkbuf_4
XFILLER_113_597 VPWR VGND VPWR VGND sky130_ef_sc_hd__decap_12
XFILLER_98_297 VGND VGND VPWR VPWR sky130_fd_sc_hd__decap_3
X_4285_ net471 net238 net454 net249 VGND VGND VPWR VPWR _0056_ sky130_fd_sc_hd__a22oi_1
XFILLER_58_117 VPWR VGND VPWR VGND sky130_ef_sc_hd__decap_12
X_6024_ net468 net254 _1872_ VGND VGND VPWR VPWR _1873_ sky130_fd_sc_hd__nand3_1
XFILLER_104_15 VPWR VGND VPWR VGND sky130_ef_sc_hd__decap_12
XFILLER_67_673 VPWR VGND VPWR VGND sky130_ef_sc_hd__decap_12
XFILLER_82_643 VGND VGND VPWR VPWR sky130_fd_sc_hd__fill_1
XFILLER_64_19 VGND VGND VPWR VPWR sky130_fd_sc_hd__decap_8
XFILLER_27_548 VPWR VGND VPWR VGND sky130_ef_sc_hd__decap_12
XFILLER_54_389 VPWR VGND VPWR VGND sky130_ef_sc_hd__decap_12
XFILLER_80_29 VGND VGND VPWR VPWR sky130_fd_sc_hd__fill_1
X_6857_ _2702_ _2782_ VGND VGND VPWR VPWR _2784_ sky130_fd_sc_hd__xnor2_1
XFILLER_22_231 VGND VGND VPWR VPWR sky130_fd_sc_hd__fill_1
X_5808_ _1635_ _1636_ _1631_ VGND VGND VPWR VPWR _1639_ sky130_fd_sc_hd__a21o_1
XFILLER_22_253 VGND VGND VPWR VPWR sky130_fd_sc_hd__decap_8
X_6788_ net382 net218 net301 net276 VGND VGND VPWR VPWR _2708_ sky130_fd_sc_hd__and4_1
XFILLER_10_437 VGND VGND VPWR VPWR sky130_fd_sc_hd__decap_8
X_5739_ _1429_ _1432_ _1562_ _1563_ VGND VGND VPWR VPWR _1564_ sky130_fd_sc_hd__o211a_1
XFILLER_6_419 VGND VGND VPWR VPWR sky130_fd_sc_hd__fill_1
XTAP_TAPCELL_ROW_20_487 VGND VPWR sky130_fd_sc_hd__tapvpwrvgnd_1
XFILLER_104_531 VGND VGND VPWR VPWR sky130_fd_sc_hd__fill_1
XFILLER_89_231 VGND VGND VPWR VPWR sky130_fd_sc_hd__fill_1
XFILLER_2_625 VPWR VGND VPWR VGND sky130_ef_sc_hd__decap_12
XFILLER_2_669 VPWR VGND VPWR VGND sky130_ef_sc_hd__decap_12
XFILLER_49_106 VGND VGND VPWR VPWR sky130_fd_sc_hd__decap_6
XFILLER_49_117 VPWR VGND VPWR VGND sky130_ef_sc_hd__decap_12
XFILLER_38_53 VGND VGND VPWR VPWR sky130_fd_sc_hd__decap_8
XFILLER_92_429 VGND VGND VPWR VPWR sky130_fd_sc_hd__decap_4
XFILLER_85_470 VGND VGND VPWR VPWR sky130_fd_sc_hd__decap_8
XFILLER_57_150 VGND VGND VPWR VPWR sky130_fd_sc_hd__fill_1
XFILLER_38_64 VGND VGND VPWR VPWR sky130_fd_sc_hd__fill_1
XFILLER_45_301 VPWR VGND VPWR VGND sky130_ef_sc_hd__decap_12
XTAP_TAPCELL_ROW_86_1279 VGND VPWR sky130_fd_sc_hd__tapvpwrvgnd_1
XFILLER_54_41 VGND VGND VPWR VPWR sky130_fd_sc_hd__decap_8
XFILLER_72_197 VGND VGND VPWR VPWR sky130_fd_sc_hd__decap_4
XTAP_TAPCELL_ROW_28_587 VGND VPWR sky130_fd_sc_hd__tapvpwrvgnd_1
XFILLER_60_348 VGND VGND VPWR VPWR sky130_fd_sc_hd__fill_1
XFILLER_54_85 VGND VGND VPWR VPWR sky130_fd_sc_hd__decap_4
XFILLER_110_91 VGND VGND VPWR VPWR sky130_fd_sc_hd__fill_1
XFILLER_13_297 VPWR VGND VPWR VGND sky130_ef_sc_hd__decap_12
XFILLER_5_496 VGND VGND VPWR VPWR sky130_fd_sc_hd__decap_8
XFILLER_110_501 VPWR VGND VPWR VGND sky130_ef_sc_hd__decap_12
XFILLER_95_223 VGND VGND VPWR VPWR sky130_fd_sc_hd__fill_1
XFILLER_110_545 VPWR VGND VPWR VGND sky130_ef_sc_hd__decap_12
XFILLER_68_448 VPWR VGND VPWR VGND sky130_ef_sc_hd__decap_12
XFILLER_1_691 VGND VGND VPWR VPWR sky130_fd_sc_hd__fill_1
X_4070_ _3234_ _3253_ _3247_ VGND VGND VPWR VPWR _3255_ sky130_fd_sc_hd__a21o_1
XFILLER_110_589 VPWR VGND VPWR VGND sky130_ef_sc_hd__decap_12
XFILLER_49_673 VPWR VGND VPWR VGND sky130_ef_sc_hd__decap_12
XFILLER_64_643 VGND VGND VPWR VPWR sky130_fd_sc_hd__fill_1
XFILLER_36_323 VGND VGND VPWR VPWR sky130_fd_sc_hd__fill_2
XFILLER_91_484 VGND VGND VPWR VPWR sky130_fd_sc_hd__fill_1
X_4972_ _0640_ _0728_ VGND VGND VPWR VPWR _0730_ sky130_fd_sc_hd__and2_1
XTAP_TAPCELL_ROW_63_1010 VGND VPWR sky130_fd_sc_hd__tapvpwrvgnd_1
XFILLER_36_389 VPWR VGND VPWR VGND sky130_ef_sc_hd__decap_12
XFILLER_51_337 VGND VGND VPWR VPWR sky130_fd_sc_hd__fill_2
X_3923_ _3111_ _3113_ VGND VGND VPWR VPWR _3114_ sky130_fd_sc_hd__nand2_2
X_6711_ _2621_ _2623_ VGND VGND VPWR VPWR _2624_ sky130_fd_sc_hd__nor2_1
X_6642_ _2526_ _2546_ VGND VGND VPWR VPWR _2548_ sky130_fd_sc_hd__xor2_1
X_3854_ net259 net324 VGND VGND VPWR VPWR _3048_ sky130_fd_sc_hd__and2_2
X_3785_ net431 net345 VGND VGND VPWR VPWR _2982_ sky130_fd_sc_hd__nor2_1
X_6573_ _2473_ VGND VGND VPWR VPWR _2474_ sky130_fd_sc_hd__inv_2
X_5524_ _1326_ _1327_ _1114_ _1116_ VGND VGND VPWR VPWR _1329_ sky130_fd_sc_hd__a211o_1
X_5455_ _1230_ _1249_ _1251_ VGND VGND VPWR VPWR _1253_ sky130_fd_sc_hd__and3_2
X_4406_ _1757_ _0171_ VGND VGND VPWR VPWR _0173_ sky130_fd_sc_hd__xnor2_1
Xfanout214 net217 VGND VGND VPWR VPWR net214 sky130_fd_sc_hd__buf_2
Xfanout203 net204 VGND VGND VPWR VPWR net203 sky130_fd_sc_hd__clkbuf_2
XFILLER_99_573 VPWR VGND VPWR VGND sky130_ef_sc_hd__decap_12
X_5386_ _1176_ _1177_ VGND VGND VPWR VPWR _1178_ sky130_fd_sc_hd__xor2_1
XFILLER_113_361 VPWR VGND VPWR VGND sky130_ef_sc_hd__decap_12
X_4337_ _0102_ _0103_ _0105_ VGND VGND VPWR VPWR _0106_ sky130_fd_sc_hd__and3_1
Xfanout225 net226 VGND VGND VPWR VPWR net225 sky130_fd_sc_hd__buf_2
Xfanout236 net237 VGND VGND VPWR VPWR net236 sky130_fd_sc_hd__clkbuf_4
Xfanout247 net248 VGND VGND VPWR VPWR net247 sky130_fd_sc_hd__buf_2
XFILLER_115_69 VPWR VGND VPWR VGND sky130_ef_sc_hd__decap_12
X_4268_ _3107_ _3134_ _0042_ net120 VGND VGND VPWR VPWR _0043_ sky130_fd_sc_hd__a22o_1
Xfanout258 net259 VGND VGND VPWR VPWR net258 sky130_fd_sc_hd__clkbuf_4
Xfanout269 net270 VGND VGND VPWR VPWR net269 sky130_fd_sc_hd__buf_2
X_6007_ _1671_ _1673_ _1853_ _1854_ VGND VGND VPWR VPWR _1856_ sky130_fd_sc_hd__a211oi_2
XFILLER_39_194 VGND VGND VPWR VPWR sky130_fd_sc_hd__decap_8
X_4199_ _3321_ _3334_ _3353_ _3377_ VGND VGND VPWR VPWR _3378_ sky130_fd_sc_hd__a31o_1
XFILLER_55_665 VGND VGND VPWR VPWR sky130_fd_sc_hd__decap_6
XFILLER_54_153 VGND VGND VPWR VPWR sky130_fd_sc_hd__fill_2
XFILLER_54_131 VGND VGND VPWR VPWR sky130_fd_sc_hd__fill_1
XFILLER_27_345 VPWR VGND VPWR VGND sky130_ef_sc_hd__decap_12
XFILLER_70_635 VGND VGND VPWR VPWR sky130_fd_sc_hd__decap_8
XFILLER_27_389 VGND VGND VPWR VPWR sky130_fd_sc_hd__decap_3
XFILLER_70_657 VPWR VGND VPWR VGND sky130_ef_sc_hd__decap_12
X_6909_ net180 _0003_ VGND VGND VPWR VPWR _alu_i0.Controller_i._present_state\[2\]
+ sky130_fd_sc_hd__dfxtp_1
XTAP_TAPCELL_ROW_25_546 VGND VPWR sky130_fd_sc_hd__tapvpwrvgnd_1
XTAP_TAPCELL_ROW_25_557 VGND VPWR sky130_fd_sc_hd__tapvpwrvgnd_1
XTAP_TAPCELL_ROW_53_888 VGND VPWR sky130_fd_sc_hd__tapvpwrvgnd_1
XFILLER_10_256 VGND VGND VPWR VPWR sky130_fd_sc_hd__decap_8
XFILLER_108_122 VGND VGND VPWR VPWR sky130_fd_sc_hd__decap_6
XFILLER_10_278 VGND VGND VPWR VPWR sky130_fd_sc_hd__fill_1
XFILLER_40_21 VGND VGND VPWR VPWR sky130_fd_sc_hd__decap_6
XFILLER_108_166 VGND VGND VPWR VPWR sky130_fd_sc_hd__decap_6
XFILLER_2_411 VGND VGND VPWR VPWR sky130_fd_sc_hd__decap_3
XFILLER_77_212 VGND VGND VPWR VPWR sky130_fd_sc_hd__fill_1
XFILLER_2_477 VPWR VGND VPWR VGND sky130_ef_sc_hd__decap_12
XFILLER_49_96 VGND VGND VPWR VPWR sky130_fd_sc_hd__decap_3
XTAP_TAPCELL_ROW_88_1308 VGND VPWR sky130_fd_sc_hd__tapvpwrvgnd_1
XFILLER_65_418 VPWR VGND VPWR VGND sky130_ef_sc_hd__decap_12
XFILLER_1_15 VPWR VGND VPWR VGND sky130_ef_sc_hd__decap_12
XFILLER_73_473 VGND VGND VPWR VPWR sky130_fd_sc_hd__decap_6
XFILLER_61_613 VGND VGND VPWR VPWR sky130_fd_sc_hd__decap_3
XTAP_TAPCELL_ROW_99_1437 VGND VPWR sky130_fd_sc_hd__tapvpwrvgnd_1
X_3570_ _2520_ _2553_ net241 VGND VGND VPWR VPWR _2564_ sky130_fd_sc_hd__mux2_1
XFILLER_115_615 VGND VGND VPWR VPWR sky130_fd_sc_hd__fill_1
X_5240_ net221 net60 _1017_ _1018_ VGND VGND VPWR VPWR _1019_ sky130_fd_sc_hd__a22o_1
XFILLER_102_309 VGND VGND VPWR VPWR sky130_fd_sc_hd__decap_6
X_5171_ _0942_ _0943_ VGND VGND VPWR VPWR _0944_ sky130_fd_sc_hd__and2b_1
XPHY_EDGE_ROW_18_Right_18 VGND VGND VPWR VPWR sky130_fd_sc_hd__decap_3
X_4122_ net134 _3284_ _3303_ _3304_ net128 VGND VGND VPWR VPWR _3305_ sky130_fd_sc_hd__o221a_1
XFILLER_96_587 VGND VGND VPWR VPWR sky130_fd_sc_hd__fill_1
XFILLER_83_215 VGND VGND VPWR VPWR sky130_fd_sc_hd__decap_8
X_4053_ net347 _0852_ _2040_ VGND VGND VPWR VPWR _3239_ sky130_fd_sc_hd__o21ai_1
XFILLER_28_109 VPWR VGND VPWR VGND sky130_ef_sc_hd__decap_12
Xinput3 a[11] VGND VGND VPWR VPWR net3 sky130_fd_sc_hd__clkbuf_2
XFILLER_83_237 VGND VGND VPWR VPWR sky130_fd_sc_hd__fill_1
XFILLER_49_492 VGND VGND VPWR VPWR sky130_fd_sc_hd__fill_2
XTAP_TAPCELL_ROW_108_1544 VGND VPWR sky130_fd_sc_hd__tapvpwrvgnd_1
XFILLER_37_665 VGND VGND VPWR VPWR sky130_fd_sc_hd__decap_6
XFILLER_91_281 VPWR VGND VPWR VGND sky130_ef_sc_hd__decap_12
XFILLER_64_473 VGND VGND VPWR VPWR sky130_fd_sc_hd__decap_3
XFILLER_101_27 VPWR VGND VPWR VGND sky130_ef_sc_hd__decap_12
X_4955_ net380 net189 net344 net394 VGND VGND VPWR VPWR _0713_ sky130_fd_sc_hd__a22o_1
XFILLER_52_657 VPWR VGND VPWR VGND sky130_ef_sc_hd__decap_12
XFILLER_24_348 VGND VGND VPWR VPWR sky130_fd_sc_hd__decap_4
XPHY_EDGE_ROW_27_Right_27 VGND VGND VPWR VPWR sky130_fd_sc_hd__decap_3
XFILLER_36_197 VPWR VGND VPWR VGND sky130_ef_sc_hd__decap_12
X_3906_ net220 _0939_ _3083_ VGND VGND VPWR VPWR _3098_ sky130_fd_sc_hd__a21o_1
XTAP_TAPCELL_ROW_22_516 VGND VPWR sky130_fd_sc_hd__tapvpwrvgnd_1
X_4886_ _0643_ _0644_ VGND VGND VPWR VPWR _0645_ sky130_fd_sc_hd__and2_1
XTAP_TAPCELL_ROW_50_847 VGND VPWR sky130_fd_sc_hd__tapvpwrvgnd_1
X_3837_ net338 net385 VGND VGND VPWR VPWR _3032_ sky130_fd_sc_hd__nand2b_1
XFILLER_20_565 VPWR VGND VPWR VGND sky130_ef_sc_hd__decap_12
X_6625_ net296 _2528_ _2527_ VGND VGND VPWR VPWR _2529_ sky130_fd_sc_hd__a21bo_1
X_3768_ _2943_ _2947_ VGND VGND VPWR VPWR _2966_ sky130_fd_sc_hd__nand2_1
X_6556_ net438 net213 VGND VGND VPWR VPWR _2455_ sky130_fd_sc_hd__nand2_1
X_5507_ _1184_ _1186_ _1307_ _1308_ VGND VGND VPWR VPWR _1311_ sky130_fd_sc_hd__o211ai_2
XFILLER_106_637 VGND VGND VPWR VPWR sky130_fd_sc_hd__decap_6
X_3699_ _1887_ _2898_ _2899_ VGND VGND VPWR VPWR _2900_ sky130_fd_sc_hd__or3_1
X_6487_ _2358_ _2376_ _2378_ VGND VGND VPWR VPWR _2380_ sky130_fd_sc_hd__or3_1
XFILLER_3_219 VGND VGND VPWR VPWR sky130_fd_sc_hd__decap_4
XFILLER_105_169 VGND VGND VPWR VPWR sky130_fd_sc_hd__decap_4
XPHY_EDGE_ROW_36_Right_36 VGND VGND VPWR VPWR sky130_fd_sc_hd__decap_3
X_5438_ net175 net206 net199 net6 VGND VGND VPWR VPWR _1235_ sky130_fd_sc_hd__a22o_1
XFILLER_114_681 VGND VGND VPWR VPWR sky130_fd_sc_hd__decap_8
X_5369_ net360 net339 VGND VGND VPWR VPWR _1160_ sky130_fd_sc_hd__and2_1
XFILLER_19_55 VGND VGND VPWR VPWR sky130_fd_sc_hd__fill_1
XFILLER_47_429 VGND VGND VPWR VPWR sky130_fd_sc_hd__decap_4
XTAP_TAPCELL_ROW_58_947 VGND VPWR sky130_fd_sc_hd__tapvpwrvgnd_1
XFILLER_28_643 VGND VGND VPWR VPWR sky130_fd_sc_hd__fill_1
XTAP_TAPCELL_ROW_2_274 VGND VPWR sky130_fd_sc_hd__tapvpwrvgnd_1
XFILLER_19_99 VPWR VGND VPWR VGND sky130_ef_sc_hd__decap_12
XFILLER_70_421 VPWR VGND VPWR VGND sky130_ef_sc_hd__decap_12
XFILLER_55_473 VPWR VGND VPWR VGND sky130_ef_sc_hd__decap_12
XFILLER_27_186 VGND VGND VPWR VPWR sky130_fd_sc_hd__fill_2
XPHY_EDGE_ROW_45_Right_45 VGND VGND VPWR VPWR sky130_fd_sc_hd__decap_3
XTAP_TAPCELL_ROW_83_1249 VGND VPWR sky130_fd_sc_hd__tapvpwrvgnd_1
XFILLER_15_337 VPWR VGND VPWR VGND sky130_ef_sc_hd__decap_12
XFILLER_42_178 VGND VGND VPWR VPWR sky130_fd_sc_hd__fill_2
XFILLER_7_503 VGND VGND VPWR VPWR sky130_fd_sc_hd__fill_1
XPHY_EDGE_ROW_54_Right_54 VGND VGND VPWR VPWR sky130_fd_sc_hd__decap_3
XTAP_TAPCELL_ROW_94_1378 VGND VPWR sky130_fd_sc_hd__tapvpwrvgnd_1
XFILLER_78_587 VGND VGND VPWR VPWR sky130_fd_sc_hd__fill_1
XFILLER_65_237 VGND VGND VPWR VPWR sky130_fd_sc_hd__fill_2
XFILLER_65_248 VPWR VGND VPWR VGND sky130_ef_sc_hd__decap_12
XPHY_EDGE_ROW_63_Right_63 VGND VGND VPWR VPWR sky130_fd_sc_hd__decap_3
XFILLER_19_665 VGND VGND VPWR VPWR sky130_fd_sc_hd__decap_6
XFILLER_18_153 VPWR VGND VPWR VGND sky130_ef_sc_hd__decap_12
XFILLER_34_613 VPWR VGND VPWR VGND sky130_ef_sc_hd__decap_12
XFILLER_46_462 VGND VGND VPWR VPWR sky130_fd_sc_hd__fill_1
XFILLER_46_473 VGND VGND VPWR VPWR sky130_fd_sc_hd__decap_3
XFILLER_73_281 VGND VGND VPWR VPWR sky130_fd_sc_hd__fill_1
XFILLER_18_197 VPWR VGND VPWR VGND sky130_ef_sc_hd__decap_12
XFILLER_33_134 VGND VGND VPWR VPWR sky130_fd_sc_hd__decap_6
XFILLER_34_657 VPWR VGND VPWR VGND sky130_ef_sc_hd__decap_12
XTAP_TAPCELL_ROW_103_1485 VGND VPWR sky130_fd_sc_hd__tapvpwrvgnd_1
X_4740_ _0489_ _0500_ VGND VGND VPWR VPWR _0501_ sky130_fd_sc_hd__and2b_1
XFILLER_14_381 VPWR VGND VPWR VGND sky130_ef_sc_hd__decap_12
X_4671_ _2281_ _0432_ VGND VGND VPWR VPWR _0433_ sky130_fd_sc_hd__nand2b_1
X_3622_ net231 _2825_ VGND VGND VPWR VPWR _2826_ sky130_fd_sc_hd__nand2_1
X_6410_ _2080_ _2082_ _2294_ VGND VGND VPWR VPWR _2296_ sky130_fd_sc_hd__o21ai_1
XPHY_EDGE_ROW_72_Right_72 VGND VGND VPWR VPWR sky130_fd_sc_hd__decap_3
X_6341_ _2197_ _2218_ _2219_ VGND VGND VPWR VPWR _2220_ sky130_fd_sc_hd__nor3_2
X_3553_ net400 net392 net378 net370 net354 net288 VGND VGND VPWR VPWR _2379_ sky130_fd_sc_hd__mux4_1
XFILLER_88_307 VGND VGND VPWR VPWR sky130_fd_sc_hd__fill_1
X_3484_ _1615_ VGND VGND VPWR VPWR _1626_ sky130_fd_sc_hd__inv_2
X_6272_ _2142_ _2143_ _1977_ _1979_ VGND VGND VPWR VPWR _2145_ sky130_fd_sc_hd__o211a_1
XFILLER_103_629 VPWR VGND VPWR VGND sky130_ef_sc_hd__decap_12
XFILLER_102_106 VGND VGND VPWR VPWR sky130_fd_sc_hd__fill_1
XFILLER_88_318 VGND VGND VPWR VPWR sky130_fd_sc_hd__decap_8
X_5223_ net236 net224 net176 net170 VGND VGND VPWR VPWR _1000_ sky130_fd_sc_hd__nand4_1
X_5154_ _0860_ _0862_ _0923_ _0924_ VGND VGND VPWR VPWR _0925_ sky130_fd_sc_hd__o211ai_4
XFILLER_111_673 VPWR VGND VPWR VGND sky130_ef_sc_hd__decap_12
XFILLER_110_150 VGND VGND VPWR VPWR sky130_fd_sc_hd__decap_4
XFILLER_96_373 VGND VGND VPWR VPWR sky130_fd_sc_hd__decap_3
XPHY_EDGE_ROW_16_Left_133 VGND VGND VPWR VPWR sky130_fd_sc_hd__decap_3
XFILLER_29_407 VPWR VGND VPWR VGND sky130_ef_sc_hd__decap_12
X_4105_ net444 net270 _3268_ _3265_ VGND VGND VPWR VPWR _3288_ sky130_fd_sc_hd__a31o_1
XFILLER_110_161 VGND VGND VPWR VPWR sky130_fd_sc_hd__decap_8
XFILLER_96_384 VGND VGND VPWR VPWR sky130_fd_sc_hd__decap_8
XFILLER_84_546 VPWR VGND VPWR VGND sky130_ef_sc_hd__decap_12
X_5085_ _2942_ _0713_ _0712_ VGND VGND VPWR VPWR _0850_ sky130_fd_sc_hd__a21o_1
XPHY_EDGE_ROW_81_Right_81 VGND VGND VPWR VPWR sky130_fd_sc_hd__decap_3
XFILLER_112_15 VPWR VGND VPWR VGND sky130_ef_sc_hd__decap_12
X_4036_ net232 _3042_ _3221_ _1572_ VGND VGND VPWR VPWR _3223_ sky130_fd_sc_hd__a211o_1
XTAP_TAPCELL_ROW_55_917 VGND VPWR sky130_fd_sc_hd__tapvpwrvgnd_1
XTAP_TAPCELL_ROW_55_906 VGND VPWR sky130_fd_sc_hd__tapvpwrvgnd_1
XFILLER_2_91 VGND VGND VPWR VPWR sky130_fd_sc_hd__fill_1
XFILLER_64_270 VGND VGND VPWR VPWR sky130_fd_sc_hd__fill_1
XTAP_TAPCELL_ROW_69_1082 VGND VPWR sky130_fd_sc_hd__tapvpwrvgnd_1
XFILLER_52_421 VGND VGND VPWR VPWR sky130_fd_sc_hd__fill_2
XFILLER_24_167 VGND VGND VPWR VPWR sky130_fd_sc_hd__decap_6
X_5987_ _1831_ _1832_ _1684_ _1686_ VGND VGND VPWR VPWR _1834_ sky130_fd_sc_hd__o211a_1
XTAP_TAPCELL_ROW_35_674 VGND VPWR sky130_fd_sc_hd__tapvpwrvgnd_1
X_4938_ _0613_ _0620_ VGND VGND VPWR VPWR _0697_ sky130_fd_sc_hd__nor2_1
XANTENNA_41 net475 VGND VGND VPWR VPWR sky130_fd_sc_hd__diode_2
X_4869_ _0626_ _0627_ VGND VGND VPWR VPWR _0628_ sky130_fd_sc_hd__and2b_1
XANTENNA_30 net339 VGND VGND VPWR VPWR sky130_fd_sc_hd__diode_2
XPHY_EDGE_ROW_25_Left_142 VGND VGND VPWR VPWR sky130_fd_sc_hd__decap_3
XPHY_EDGE_ROW_90_Right_90 VGND VGND VPWR VPWR sky130_fd_sc_hd__decap_3
X_6608_ net390 net263 net256 net397 VGND VGND VPWR VPWR _2511_ sky130_fd_sc_hd__a22oi_1
X_6539_ _2266_ _2268_ _2265_ VGND VGND VPWR VPWR _2437_ sky130_fd_sc_hd__o21ba_1
XFILLER_97_27 VPWR VGND VPWR VGND sky130_ef_sc_hd__decap_12
XTAP_TAPCELL_ROW_7_333 VGND VPWR sky130_fd_sc_hd__tapvpwrvgnd_1
XPHY_EDGE_ROW_34_Left_151 VGND VGND VPWR VPWR sky130_fd_sc_hd__decap_3
XFILLER_87_373 VPWR VGND VPWR VGND sky130_ef_sc_hd__decap_12
XFILLER_101_161 VGND VGND VPWR VPWR sky130_fd_sc_hd__decap_6
XFILLER_47_215 VGND VGND VPWR VPWR sky130_fd_sc_hd__fill_1
XFILLER_75_557 VGND VGND VPWR VPWR sky130_fd_sc_hd__decap_3
XFILLER_15_101 VGND VGND VPWR VPWR sky130_fd_sc_hd__fill_1
XFILLER_16_613 VPWR VGND VPWR VGND sky130_ef_sc_hd__decap_12
XFILLER_55_281 VPWR VGND VPWR VGND sky130_ef_sc_hd__decap_12
XFILLER_15_123 VPWR VGND VPWR VGND sky130_ef_sc_hd__decap_12
XFILLER_16_657 VPWR VGND VPWR VGND sky130_ef_sc_hd__decap_12
XPHY_EDGE_ROW_43_Left_160 VGND VGND VPWR VPWR sky130_fd_sc_hd__decap_3
XTAP_TAPCELL_ROW_96_1407 VGND VPWR sky130_fd_sc_hd__tapvpwrvgnd_1
XFILLER_11_351 VGND VGND VPWR VPWR sky130_fd_sc_hd__fill_1
XFILLER_7_333 VGND VGND VPWR VPWR sky130_fd_sc_hd__decap_3
XFILLER_116_209 VGND VGND VPWR VPWR sky130_fd_sc_hd__decap_6
XFILLER_7_69 VGND VGND VPWR VPWR sky130_fd_sc_hd__decap_6
XFILLER_109_261 VGND VGND VPWR VPWR sky130_fd_sc_hd__fill_2
XFILLER_7_377 VGND VGND VPWR VPWR sky130_fd_sc_hd__fill_1
XFILLER_3_561 VPWR VGND VPWR VGND sky130_ef_sc_hd__decap_12
XFILLER_97_137 VPWR VGND VPWR VGND sky130_ef_sc_hd__decap_12
XFILLER_78_362 VGND VGND VPWR VPWR sky130_fd_sc_hd__fill_2
XFILLER_38_204 VPWR VGND VPWR VGND sky130_ef_sc_hd__decap_12
XFILLER_38_237 VPWR VGND VPWR VGND sky130_ef_sc_hd__decap_12
XFILLER_81_505 VPWR VGND VPWR VGND sky130_ef_sc_hd__decap_12
XTAP_TAPCELL_ROW_105_1514 VGND VPWR sky130_fd_sc_hd__tapvpwrvgnd_1
X_5910_ _1748_ _1749_ VGND VGND VPWR VPWR _1750_ sky130_fd_sc_hd__xnor2_1
XFILLER_19_473 VGND VGND VPWR VPWR sky130_fd_sc_hd__decap_4
X_6890_ net183 _alu_i0.Datapath_i.fu_alu_33673_33851.out1\[16\] VGND VGND VPWR VPWR
+ _alu_i0.Datapath_i.reg_0.reg_out1\[16\] sky130_fd_sc_hd__dfxtp_1
XFILLER_34_443 VPWR VGND VPWR VGND sky130_ef_sc_hd__decap_12
XFILLER_61_240 VGND VGND VPWR VPWR sky130_fd_sc_hd__fill_1
X_5841_ _1488_ _1497_ _1496_ VGND VGND VPWR VPWR _1675_ sky130_fd_sc_hd__a21o_1
X_5772_ net395 net388 net299 net294 VGND VGND VPWR VPWR _1599_ sky130_fd_sc_hd__and4_1
XTAP_TAPCELL_ROW_32_633 VGND VPWR sky130_fd_sc_hd__tapvpwrvgnd_1
XFILLER_34_487 VPWR VGND VPWR VGND sky130_ef_sc_hd__decap_12
X_4723_ _0480_ _0481_ _0482_ VGND VGND VPWR VPWR _0484_ sky130_fd_sc_hd__nand3_1
XTAP_TAPCELL_ROW_60_975 VGND VPWR sky130_fd_sc_hd__tapvpwrvgnd_1
X_4654_ _0414_ _0415_ VGND VGND VPWR VPWR _0416_ sky130_fd_sc_hd__nor2_1
XTAP_TAPCELL_ROW_12_390 VGND VPWR sky130_fd_sc_hd__tapvpwrvgnd_1
Xinput61 b[6] VGND VGND VPWR VPWR net61 sky130_fd_sc_hd__buf_2
XTAP_TAPCELL_ROW_116_1643 VGND VPWR sky130_fd_sc_hd__tapvpwrvgnd_1
X_4585_ _0346_ _0347_ VGND VGND VPWR VPWR _0348_ sky130_fd_sc_hd__xnor2_1
X_3605_ _2808_ VGND VGND VPWR VPWR _2809_ sky130_fd_sc_hd__inv_2
Xinput72 opcode[6] VGND VGND VPWR VPWR net72 sky130_fd_sc_hd__clkbuf_1
Xinput50 b[25] VGND VGND VPWR VPWR net50 sky130_fd_sc_hd__clkbuf_1
XTAP_TAPCELL_ROW_116_1654 VGND VPWR sky130_fd_sc_hd__tapvpwrvgnd_1
X_3536_ _2161_ _2182_ net278 VGND VGND VPWR VPWR _2193_ sky130_fd_sc_hd__mux2_1
X_6324_ net382 net301 VGND VGND VPWR VPWR _2201_ sky130_fd_sc_hd__nand2_1
XFILLER_107_15 VPWR VGND VPWR VGND sky130_ef_sc_hd__decap_12
X_6255_ _2124_ _2125_ VGND VGND VPWR VPWR _2126_ sky130_fd_sc_hd__nand2_1
XFILLER_88_137 VGND VGND VPWR VPWR sky130_fd_sc_hd__decap_3
X_5206_ _0869_ _0871_ _0979_ _0981_ VGND VGND VPWR VPWR _0982_ sky130_fd_sc_hd__a211oi_1
X_3467_ net347 _0885_ _1430_ VGND VGND VPWR VPWR _1441_ sky130_fd_sc_hd__o21ai_2
XFILLER_97_671 VGND VGND VPWR VPWR sky130_fd_sc_hd__fill_1
XTAP_TAPCELL_ROW_4_303 VGND VPWR sky130_fd_sc_hd__tapvpwrvgnd_1
X_6186_ _2049_ VGND VGND VPWR VPWR _2050_ sky130_fd_sc_hd__inv_2
X_5137_ _2018_ _0904_ VGND VGND VPWR VPWR _0907_ sky130_fd_sc_hd__xnor2_1
X_5068_ net290 net173 VGND VGND VPWR VPWR _0832_ sky130_fd_sc_hd__nand2_1
XFILLER_57_546 VGND VGND VPWR VPWR sky130_fd_sc_hd__fill_1
XFILLER_84_398 VGND VGND VPWR VPWR sky130_fd_sc_hd__decap_3
XFILLER_84_365 VPWR VGND VPWR VGND sky130_ef_sc_hd__decap_12
X_4019_ _3200_ _3204_ VGND VGND VPWR VPWR _3206_ sky130_fd_sc_hd__or2_1
XFILLER_37_281 VPWR VGND VPWR VGND sky130_ef_sc_hd__decap_12
XTAP_TAPCELL_ROW_80_1208 VGND VPWR sky130_fd_sc_hd__tapvpwrvgnd_1
XPHY_EDGE_ROW_0_Right_0 VGND VGND VPWR VPWR sky130_fd_sc_hd__decap_3
XFILLER_25_476 VGND VGND VPWR VPWR sky130_fd_sc_hd__decap_8
XFILLER_12_115 VGND VGND VPWR VPWR sky130_fd_sc_hd__decap_6
XFILLER_9_609 VGND VGND VPWR VPWR sky130_fd_sc_hd__decap_6
XFILLER_21_671 VGND VGND VPWR VPWR sky130_fd_sc_hd__fill_1
XFILLER_113_3 VPWR VGND VPWR VGND sky130_ef_sc_hd__decap_12
XFILLER_4_325 VGND VGND VPWR VPWR sky130_fd_sc_hd__fill_2
XFILLER_106_220 VPWR VGND VPWR VGND sky130_ef_sc_hd__decap_12
XFILLER_106_253 VPWR VGND VPWR VGND sky130_ef_sc_hd__decap_12
XFILLER_4_369 VPWR VGND VPWR VGND sky130_ef_sc_hd__decap_12
XTAP_TAPCELL_ROW_91_1348 VGND VPWR sky130_fd_sc_hd__tapvpwrvgnd_1
XFILLER_79_148 VGND VGND VPWR VPWR sky130_fd_sc_hd__decap_8
XFILLER_94_107 VGND VGND VPWR VPWR sky130_fd_sc_hd__decap_8
XFILLER_48_513 VPWR VGND VPWR VGND sky130_ef_sc_hd__decap_12
XFILLER_75_376 VGND VGND VPWR VPWR sky130_fd_sc_hd__decap_4
XFILLER_43_240 VGND VGND VPWR VPWR sky130_fd_sc_hd__decap_3
XTAP_TAPCELL_ROW_100_1455 VGND VPWR sky130_fd_sc_hd__tapvpwrvgnd_1
XFILLER_11_181 VGND VGND VPWR VPWR sky130_fd_sc_hd__decap_3
X_4370_ _0137_ VGND VGND VPWR VPWR _0138_ sky130_fd_sc_hd__inv_2
XFILLER_98_457 VGND VGND VPWR VPWR sky130_fd_sc_hd__decap_8
X_6040_ _1886_ _1888_ _1889_ VGND VGND VPWR VPWR _1891_ sky130_fd_sc_hd__a21o_1
XFILLER_39_502 VGND VGND VPWR VPWR sky130_fd_sc_hd__fill_2
XTAP_TAPCELL_ROW_111_1584 VGND VPWR sky130_fd_sc_hd__tapvpwrvgnd_1
XFILLER_100_418 VGND VGND VPWR VPWR sky130_fd_sc_hd__fill_2
XFILLER_79_671 VGND VGND VPWR VPWR sky130_fd_sc_hd__fill_1
XFILLER_39_513 VPWR VGND VPWR VGND sky130_ef_sc_hd__decap_12
XFILLER_66_343 VPWR VGND VPWR VGND sky130_ef_sc_hd__decap_12
XFILLER_81_302 VGND VGND VPWR VPWR sky130_fd_sc_hd__decap_4
XFILLER_66_365 VGND VGND VPWR VPWR sky130_fd_sc_hd__decap_8
XFILLER_19_281 VPWR VGND VPWR VGND sky130_ef_sc_hd__decap_12
XTAP_TAPCELL_ROW_66_1041 VGND VPWR sky130_fd_sc_hd__tapvpwrvgnd_1
X_6873_ _0776_ net179 _1113_ _0000_ VGND VGND VPWR VPWR _0003_ sky130_fd_sc_hd__o31a_1
XTAP_TAPCELL_ROW_17_460 VGND VPWR sky130_fd_sc_hd__tapvpwrvgnd_1
X_5824_ _1523_ _1654_ _1655_ VGND VGND VPWR VPWR _1656_ sky130_fd_sc_hd__and3_1
XTAP_TAPCELL_ROW_45_791 VGND VPWR sky130_fd_sc_hd__tapvpwrvgnd_1
XFILLER_22_457 VGND VGND VPWR VPWR sky130_fd_sc_hd__decap_8
X_5755_ _1447_ _1450_ _1578_ _1579_ VGND VGND VPWR VPWR _1581_ sky130_fd_sc_hd__a211o_1
X_4706_ _0398_ _0400_ VGND VGND VPWR VPWR _0468_ sky130_fd_sc_hd__or2_1
X_5686_ net360 net322 _1502_ _1503_ VGND VGND VPWR VPWR _1505_ sky130_fd_sc_hd__a22o_1
X_4637_ _0308_ _0311_ _0398_ _0399_ VGND VGND VPWR VPWR _0400_ sky130_fd_sc_hd__a211oi_1
X_4568_ _0269_ _0329_ _0330_ VGND VGND VPWR VPWR _0332_ sky130_fd_sc_hd__nand3b_2
XFILLER_78_29 VGND VGND VPWR VPWR sky130_fd_sc_hd__decap_8
XTAP_TAPCELL_ROW_77_1181 VGND VPWR sky130_fd_sc_hd__tapvpwrvgnd_1
XTAP_TAPCELL_ROW_77_1170 VGND VPWR sky130_fd_sc_hd__tapvpwrvgnd_1
X_4499_ _0194_ _0262_ VGND VGND VPWR VPWR _0264_ sky130_fd_sc_hd__xnor2_1
XFILLER_89_446 VGND VGND VPWR VPWR sky130_fd_sc_hd__fill_2
X_3519_ net130 _1898_ _1975_ _1997_ VGND VGND VPWR VPWR _2008_ sky130_fd_sc_hd__o22a_1
X_6307_ net413 net405 net263 net256 VGND VGND VPWR VPWR _2183_ sky130_fd_sc_hd__and4_1
XFILLER_89_479 VPWR VGND VPWR VGND sky130_ef_sc_hd__decap_12
X_6238_ _2065_ _2067_ _2105_ _2107_ VGND VGND VPWR VPWR _2108_ sky130_fd_sc_hd__or4_4
X_6169_ _2019_ _2021_ _2030_ VGND VGND VPWR VPWR _2032_ sky130_fd_sc_hd__a21oi_1
XFILLER_85_641 VPWR VGND VPWR VGND sky130_ef_sc_hd__decap_12
XFILLER_85_685 VGND VGND VPWR VPWR sky130_fd_sc_hd__decap_6
XFILLER_45_505 VGND VGND VPWR VPWR sky130_fd_sc_hd__decap_6
XFILLER_72_324 VGND VGND VPWR VPWR sky130_fd_sc_hd__decap_3
XFILLER_27_55 VGND VGND VPWR VPWR sky130_fd_sc_hd__fill_1
XFILLER_27_77 VGND VGND VPWR VPWR sky130_fd_sc_hd__fill_2
XFILLER_53_571 VPWR VGND VPWR VGND sky130_ef_sc_hd__decap_12
XFILLER_40_243 VGND VGND VPWR VPWR sky130_fd_sc_hd__fill_1
XFILLER_43_43 VPWR VGND VPWR VGND sky130_ef_sc_hd__decap_12
XFILLER_4_122 VGND VGND VPWR VPWR sky130_fd_sc_hd__fill_1
XFILLER_107_573 VPWR VGND VPWR VGND sky130_ef_sc_hd__decap_12
XFILLER_4_15 VPWR VGND VPWR VGND sky130_ef_sc_hd__decap_12
XFILLER_4_177 VPWR VGND VPWR VGND sky130_ef_sc_hd__decap_12
XFILLER_95_449 VGND VGND VPWR VPWR sky130_fd_sc_hd__decap_3
XFILLER_36_516 VPWR VGND VPWR VGND sky130_ef_sc_hd__decap_12
XFILLER_48_365 VGND VGND VPWR VPWR sky130_fd_sc_hd__decap_6
XFILLER_48_376 VGND VGND VPWR VPWR sky130_fd_sc_hd__decap_3
XFILLER_63_335 VGND VGND VPWR VPWR sky130_fd_sc_hd__fill_1
XFILLER_36_549 VGND VGND VPWR VPWR sky130_fd_sc_hd__fill_1
XFILLER_63_357 VGND VGND VPWR VPWR sky130_fd_sc_hd__fill_2
XFILLER_16_240 VPWR VGND VPWR VGND sky130_ef_sc_hd__decap_12
XFILLER_90_176 VPWR VGND VPWR VGND sky130_ef_sc_hd__decap_12
XFILLER_44_571 VPWR VGND VPWR VGND sky130_ef_sc_hd__decap_12
X_3870_ net163 net260 _2281_ VGND VGND VPWR VPWR _3064_ sky130_fd_sc_hd__a21bo_1
XTAP_TAPCELL_ROW_42_750 VGND VPWR sky130_fd_sc_hd__tapvpwrvgnd_1
XTAP_TAPCELL_ROW_42_761 VGND VPWR sky130_fd_sc_hd__tapvpwrvgnd_1
XFILLER_76_3 VPWR VGND VPWR VGND sky130_ef_sc_hd__decap_12
X_5540_ net283 net446 VGND VGND VPWR VPWR _1346_ sky130_fd_sc_hd__and2_1
X_5471_ _1151_ _1270_ VGND VGND VPWR VPWR _1271_ sky130_fd_sc_hd__nor2_1
X_4422_ net455 net426 net208 net201 VGND VGND VPWR VPWR _0188_ sky130_fd_sc_hd__and4_1
XTAP_TAPCELL_ROW_113_1613 VGND VPWR sky130_fd_sc_hd__tapvpwrvgnd_1
XTAP_TAPCELL_ROW_113_1602 VGND VPWR sky130_fd_sc_hd__tapvpwrvgnd_1
X_4353_ _0119_ _0120_ VGND VGND VPWR VPWR _0121_ sky130_fd_sc_hd__nor2_1
Xfanout407 net408 VGND VGND VPWR VPWR net407 sky130_fd_sc_hd__dlymetal6s2s_1
XFILLER_98_265 VPWR VGND VPWR VGND sky130_ef_sc_hd__decap_12
X_4284_ _alu_i0.Datapath_i.reg_0.reg_out1\[2\] net149 _0054_ _0055_ VGND VGND VPWR
+ VPWR net99 sky130_fd_sc_hd__a22o_1
Xfanout418 net26 VGND VGND VPWR VPWR net418 sky130_fd_sc_hd__buf_4
Xfanout429 net430 VGND VGND VPWR VPWR net429 sky130_fd_sc_hd__clkbuf_4
XFILLER_58_129 VGND VGND VPWR VPWR sky130_fd_sc_hd__decap_4
X_6023_ _1869_ _1870_ VGND VGND VPWR VPWR _1872_ sky130_fd_sc_hd__xnor2_1
XFILLER_104_27 VGND VGND VPWR VPWR sky130_fd_sc_hd__fill_1
XFILLER_100_248 VGND VGND VPWR VPWR sky130_fd_sc_hd__decap_4
XFILLER_100_237 VGND VGND VPWR VPWR sky130_fd_sc_hd__decap_4
XFILLER_67_685 VGND VGND VPWR VPWR sky130_fd_sc_hd__decap_6
XFILLER_39_365 VGND VGND VPWR VPWR sky130_fd_sc_hd__decap_3
XFILLER_81_110 VGND VGND VPWR VPWR sky130_fd_sc_hd__fill_2
XFILLER_54_313 VPWR VGND VPWR VGND sky130_ef_sc_hd__decap_12
X_6856_ _2748_ _2780_ VGND VGND VPWR VPWR _2782_ sky130_fd_sc_hd__xnor2_1
X_5807_ _1631_ _1635_ _1636_ VGND VGND VPWR VPWR _1638_ sky130_fd_sc_hd__nand3_1
X_6787_ net218 net301 net276 net382 VGND VGND VPWR VPWR _2707_ sky130_fd_sc_hd__a22oi_1
X_3999_ net140 _3181_ _3186_ net126 VGND VGND VPWR VPWR _3187_ sky130_fd_sc_hd__a2bb2o_1
XFILLER_13_57 VPWR VGND VPWR VGND sky130_ef_sc_hd__decap_12
X_5738_ _1542_ _1559_ _1560_ VGND VGND VPWR VPWR _1563_ sky130_fd_sc_hd__nand3_2
XFILLER_89_17 VGND VGND VPWR VPWR sky130_fd_sc_hd__fill_2
XTAP_TAPCELL_ROW_20_488 VGND VPWR sky130_fd_sc_hd__tapvpwrvgnd_1
X_5669_ net175 net192 VGND VGND VPWR VPWR _1487_ sky130_fd_sc_hd__nand2_1
XFILLER_89_210 VPWR VGND VPWR VGND sky130_ef_sc_hd__decap_12
XFILLER_2_637 VGND VGND VPWR VPWR sky130_fd_sc_hd__decap_6
XPHY_EDGE_ROW_8_Left_125 VGND VGND VPWR VPWR sky130_fd_sc_hd__decap_3
XFILLER_104_587 VGND VGND VPWR VPWR sky130_fd_sc_hd__fill_1
XFILLER_1_169 VGND VGND VPWR VPWR sky130_fd_sc_hd__decap_3
XFILLER_49_129 VGND VGND VPWR VPWR sky130_fd_sc_hd__decap_6
XFILLER_77_449 VPWR VGND VPWR VGND sky130_ef_sc_hd__decap_12
XFILLER_58_641 VGND VGND VPWR VPWR sky130_fd_sc_hd__decap_3
XFILLER_92_408 VGND VGND VPWR VPWR sky130_fd_sc_hd__decap_4
XFILLER_38_76 VGND VGND VPWR VPWR sky130_fd_sc_hd__fill_1
XFILLER_85_493 VGND VGND VPWR VPWR sky130_fd_sc_hd__decap_8
XFILLER_18_549 VGND VGND VPWR VPWR sky130_fd_sc_hd__fill_2
XFILLER_45_313 VPWR VGND VPWR VGND sky130_ef_sc_hd__decap_12
XFILLER_45_368 VPWR VGND VPWR VGND sky130_ef_sc_hd__decap_12
XFILLER_60_327 VGND VGND VPWR VPWR sky130_fd_sc_hd__fill_1
XFILLER_54_64 VPWR VGND VPWR VGND sky130_ef_sc_hd__decap_12
XTAP_TAPCELL_ROW_28_588 VGND VPWR sky130_fd_sc_hd__tapvpwrvgnd_1
XFILLER_41_541 VGND VGND VPWR VPWR sky130_fd_sc_hd__fill_1
XFILLER_9_203 VPWR VGND VPWR VGND sky130_ef_sc_hd__decap_12
XFILLER_70_52 VGND VGND VPWR VPWR sky130_fd_sc_hd__decap_3
XFILLER_70_41 VGND VGND VPWR VPWR sky130_fd_sc_hd__decap_8
XFILLER_48_7 VPWR VGND VPWR VGND sky130_ef_sc_hd__decap_12
XFILLER_110_513 VPWR VGND VPWR VGND sky130_ef_sc_hd__decap_12
XFILLER_110_557 VPWR VGND VPWR VGND sky130_ef_sc_hd__decap_12
XFILLER_49_641 VPWR VGND VPWR VGND sky130_ef_sc_hd__decap_12
XFILLER_95_93 VGND VGND VPWR VPWR sky130_fd_sc_hd__decap_4
XFILLER_95_60 VGND VGND VPWR VPWR sky130_fd_sc_hd__decap_8
XFILLER_49_685 VGND VGND VPWR VPWR sky130_fd_sc_hd__decap_6
XFILLER_63_121 VGND VGND VPWR VPWR sky130_fd_sc_hd__fill_1
XTAP_TAPCELL_ROW_47_820 VGND VPWR sky130_fd_sc_hd__tapvpwrvgnd_1
X_4971_ _0640_ _0728_ VGND VGND VPWR VPWR _0729_ sky130_fd_sc_hd__nor2_1
XFILLER_17_582 VPWR VGND VPWR VGND sky130_ef_sc_hd__decap_12
XTAP_TAPCELL_ROW_63_1011 VGND VPWR sky130_fd_sc_hd__tapvpwrvgnd_1
X_3922_ net170 net306 VGND VGND VPWR VPWR _3113_ sky130_fd_sc_hd__or2_1
XFILLER_32_530 VGND VGND VPWR VPWR sky130_fd_sc_hd__fill_2
X_6710_ net440 net438 net205 net198 VGND VGND VPWR VPWR _2623_ sky130_fd_sc_hd__and4_1
X_3853_ _3040_ _3045_ _3047_ VGND VGND VPWR VPWR _alu_i0.Datapath_i.fu_alu_33673_33851.out1\[12\]
+ sky130_fd_sc_hd__or3_1
X_6641_ _2526_ _2546_ VGND VGND VPWR VPWR _2547_ sky130_fd_sc_hd__and2b_1
X_3784_ net433 net342 VGND VGND VPWR VPWR _2981_ sky130_fd_sc_hd__and2_2
X_6572_ _2256_ _2258_ _2471_ _2472_ VGND VGND VPWR VPWR _2473_ sky130_fd_sc_hd__a211o_1
X_5523_ _1114_ _1116_ _1326_ _1327_ VGND VGND VPWR VPWR _1328_ sky130_fd_sc_hd__o211ai_2
XFILLER_8_280 VPWR VGND VPWR VGND sky130_ef_sc_hd__decap_12
X_5454_ _1249_ _1251_ _1230_ VGND VGND VPWR VPWR _1252_ sky130_fd_sc_hd__a21oi_1
X_4405_ net355 net377 _0171_ VGND VGND VPWR VPWR _0172_ sky130_fd_sc_hd__and3_1
X_5385_ net389 net320 VGND VGND VPWR VPWR _1177_ sky130_fd_sc_hd__nand2_1
Xfanout204 net62 VGND VGND VPWR VPWR net204 sky130_fd_sc_hd__clkbuf_2
XFILLER_99_541 VPWR VGND VPWR VGND sky130_ef_sc_hd__decap_12
X_4336_ net286 net414 _0078_ _0077_ VGND VGND VPWR VPWR _0105_ sky130_fd_sc_hd__a31o_1
XTAP_TAPCELL_ROW_74_1140 VGND VPWR sky130_fd_sc_hd__tapvpwrvgnd_1
XFILLER_5_91 VPWR VGND VPWR VGND sky130_ef_sc_hd__decap_12
XFILLER_115_15 VPWR VGND VPWR VGND sky130_ef_sc_hd__decap_12
XFILLER_113_373 VGND VGND VPWR VPWR sky130_fd_sc_hd__decap_8
Xfanout215 net217 VGND VGND VPWR VPWR net215 sky130_fd_sc_hd__clkbuf_4
XFILLER_99_585 VPWR VGND VPWR VGND sky130_ef_sc_hd__decap_12
Xfanout226 net230 VGND VGND VPWR VPWR net226 sky130_fd_sc_hd__clkbuf_2
Xfanout237 net243 VGND VGND VPWR VPWR net237 sky130_fd_sc_hd__clkbuf_2
XFILLER_59_405 VPWR VGND VPWR VGND sky130_ef_sc_hd__decap_12
XFILLER_101_546 VPWR VGND VPWR VGND sky130_ef_sc_hd__decap_12
Xfanout248 net55 VGND VGND VPWR VPWR net248 sky130_fd_sc_hd__clkbuf_4
XFILLER_59_449 VPWR VGND VPWR VGND sky130_ef_sc_hd__decap_12
X_4267_ net157 _3279_ _0038_ _0040_ VGND VGND VPWR VPWR _0042_ sky130_fd_sc_hd__o22a_1
Xfanout259 net5 VGND VGND VPWR VPWR net259 sky130_fd_sc_hd__buf_4
XFILLER_86_268 VGND VGND VPWR VPWR sky130_fd_sc_hd__fill_1
XFILLER_39_140 VPWR VGND VPWR VGND sky130_ef_sc_hd__decap_12
X_4198_ _0895_ net52 _3376_ VGND VGND VPWR VPWR _3377_ sky130_fd_sc_hd__o21ai_1
X_6006_ _1851_ _1852_ _1707_ _1709_ VGND VGND VPWR VPWR _1854_ sky130_fd_sc_hd__o211a_1
XFILLER_54_110 VGND VGND VPWR VPWR sky130_fd_sc_hd__decap_6
XFILLER_27_335 VGND VGND VPWR VPWR sky130_fd_sc_hd__fill_1
XFILLER_27_357 VPWR VGND VPWR VGND sky130_ef_sc_hd__decap_12
XFILLER_70_669 VPWR VGND VPWR VGND sky130_ef_sc_hd__decap_12
X_6908_ net180 _0002_ VGND VGND VPWR VPWR _alu_i0.Controller_i._present_state\[1\]
+ sky130_fd_sc_hd__dfxtp_1
XFILLER_23_530 VGND VGND VPWR VPWR sky130_fd_sc_hd__fill_1
XTAP_TAPCELL_ROW_25_547 VGND VPWR sky130_fd_sc_hd__tapvpwrvgnd_1
XFILLER_42_349 VGND VGND VPWR VPWR sky130_fd_sc_hd__decap_3
XTAP_TAPCELL_ROW_53_889 VGND VPWR sky130_fd_sc_hd__tapvpwrvgnd_1
X_6839_ net449 net336 VGND VGND VPWR VPWR _2764_ sky130_fd_sc_hd__nand2_1
XFILLER_6_206 VGND VGND VPWR VPWR sky130_fd_sc_hd__fill_2
XFILLER_104_340 VGND VGND VPWR VPWR sky130_fd_sc_hd__decap_6
XFILLER_6_3 VPWR VGND VPWR VGND sky130_ef_sc_hd__decap_12
XFILLER_2_434 VPWR VGND VPWR VGND sky130_ef_sc_hd__decap_12
XFILLER_2_489 VPWR VGND VPWR VGND sky130_ef_sc_hd__decap_12
XFILLER_49_53 VGND VGND VPWR VPWR sky130_fd_sc_hd__decap_3
XFILLER_92_205 VGND VGND VPWR VPWR sky130_fd_sc_hd__decap_3
XTAP_TAPCELL_ROW_88_1309 VGND VPWR sky130_fd_sc_hd__tapvpwrvgnd_1
XFILLER_1_27 VPWR VGND VPWR VGND sky130_ef_sc_hd__decap_12
XFILLER_45_143 VGND VGND VPWR VPWR sky130_fd_sc_hd__fill_1
XFILLER_33_305 VPWR VGND VPWR VGND sky130_ef_sc_hd__decap_12
XFILLER_45_176 VPWR VGND VPWR VGND sky130_ef_sc_hd__decap_12
XFILLER_81_51 VGND VGND VPWR VPWR sky130_fd_sc_hd__decap_4
XFILLER_41_393 VGND VGND VPWR VPWR sky130_fd_sc_hd__decap_6
XTAP_TAPCELL_ROW_99_1438 VGND VPWR sky130_fd_sc_hd__tapvpwrvgnd_1
XFILLER_114_148 VPWR VGND VPWR VGND sky130_ef_sc_hd__decap_12
XFILLER_96_500 VPWR VGND VPWR VGND sky130_ef_sc_hd__decap_12
X_5170_ net365 net187 net342 net372 VGND VGND VPWR VPWR _0943_ sky130_fd_sc_hd__a22o_1
XFILLER_68_213 VGND VGND VPWR VPWR sky130_fd_sc_hd__decap_8
XFILLER_39_3 VPWR VGND VPWR VGND sky130_ef_sc_hd__decap_12
XFILLER_110_321 VPWR VGND VPWR VGND sky130_ef_sc_hd__decap_12
X_4121_ net142 _3283_ net134 VGND VGND VPWR VPWR _3304_ sky130_fd_sc_hd__o21ai_1
XFILLER_110_365 VGND VGND VPWR VPWR sky130_fd_sc_hd__decap_6
X_4052_ net132 _3228_ _3237_ _1539_ VGND VGND VPWR VPWR _3238_ sky130_fd_sc_hd__a211o_1
XFILLER_49_460 VPWR VGND VPWR VGND sky130_ef_sc_hd__decap_12
Xinput4 a[12] VGND VGND VPWR VPWR net4 sky130_fd_sc_hd__buf_2
XFILLER_36_110 VPWR VGND VPWR VGND sky130_ef_sc_hd__decap_12
XFILLER_37_611 VGND VGND VPWR VPWR sky130_fd_sc_hd__decap_4
XTAP_TAPCELL_ROW_108_1545 VGND VPWR sky130_fd_sc_hd__tapvpwrvgnd_1
XFILLER_76_290 VPWR VGND VPWR VGND sky130_ef_sc_hd__decap_12
XFILLER_101_39 VPWR VGND VPWR VGND sky130_ef_sc_hd__decap_12
XFILLER_91_293 VPWR VGND VPWR VGND sky130_ef_sc_hd__decap_12
X_4954_ net394 net380 net189 net344 VGND VGND VPWR VPWR _0712_ sky130_fd_sc_hd__and4_1
XFILLER_52_669 VPWR VGND VPWR VGND sky130_ef_sc_hd__decap_12
XFILLER_17_390 VGND VGND VPWR VPWR sky130_fd_sc_hd__fill_2
XFILLER_51_113 VGND VGND VPWR VPWR sky130_fd_sc_hd__fill_1
X_3905_ _3094_ _3095_ VGND VGND VPWR VPWR _3097_ sky130_fd_sc_hd__or2_2
X_4885_ _0559_ _0642_ VGND VGND VPWR VPWR _0644_ sky130_fd_sc_hd__nand2_1
XFILLER_20_533 VPWR VGND VPWR VGND sky130_ef_sc_hd__decap_12
XTAP_TAPCELL_ROW_22_517 VGND VPWR sky130_fd_sc_hd__tapvpwrvgnd_1
XTAP_TAPCELL_ROW_50_848 VGND VPWR sky130_fd_sc_hd__tapvpwrvgnd_1
X_3836_ net385 net339 VGND VGND VPWR VPWR _3031_ sky130_fd_sc_hd__and2b_1
X_6624_ net382 net310 net292 VGND VGND VPWR VPWR _2528_ sky130_fd_sc_hd__and3_1
XPHY_EDGE_ROW_89_Left_206 VGND VGND VPWR VPWR sky130_fd_sc_hd__decap_3
X_3767_ _2963_ _2964_ VGND VGND VPWR VPWR _2965_ sky130_fd_sc_hd__and2b_1
XFILLER_20_577 VGND VGND VPWR VPWR sky130_fd_sc_hd__decap_8
X_6555_ _2452_ _2453_ VGND VGND VPWR VPWR _2454_ sky130_fd_sc_hd__nor2_1
X_5506_ _1184_ _1186_ _1307_ _1308_ VGND VGND VPWR VPWR _1309_ sky130_fd_sc_hd__o211a_1
X_3698_ _2871_ _2897_ _2895_ VGND VGND VPWR VPWR _2899_ sky130_fd_sc_hd__a21oi_1
X_6486_ _2374_ _2375_ _2210_ _2212_ VGND VGND VPWR VPWR _2378_ sky130_fd_sc_hd__a211oi_1
X_5437_ net313 net197 _1154_ _1155_ VGND VGND VPWR VPWR _1234_ sky130_fd_sc_hd__a31o_1
XFILLER_86_29 VGND VGND VPWR VPWR sky130_fd_sc_hd__decap_6
X_5368_ _1156_ _1158_ VGND VGND VPWR VPWR _1159_ sky130_fd_sc_hd__xnor2_1
XFILLER_113_181 VGND VGND VPWR VPWR sky130_fd_sc_hd__decap_8
XFILLER_99_393 VGND VGND VPWR VPWR sky130_fd_sc_hd__decap_3
X_4319_ _0065_ _0087_ VGND VGND VPWR VPWR _0089_ sky130_fd_sc_hd__or2_1
X_5299_ _1036_ _1038_ _1079_ _1080_ VGND VGND VPWR VPWR _1084_ sky130_fd_sc_hd__a2bb2oi_1
XFILLER_59_246 VGND VGND VPWR VPWR sky130_fd_sc_hd__decap_8
XPHY_EDGE_ROW_98_Left_215 VGND VGND VPWR VPWR sky130_fd_sc_hd__decap_3
XTAP_TAPCELL_ROW_58_948 VGND VPWR sky130_fd_sc_hd__tapvpwrvgnd_1
XFILLER_55_441 VGND VGND VPWR VPWR sky130_fd_sc_hd__decap_6
XFILLER_55_485 VGND VGND VPWR VPWR sky130_fd_sc_hd__fill_2
XTAP_TAPCELL_ROW_2_275 VGND VPWR sky130_fd_sc_hd__tapvpwrvgnd_1
XFILLER_27_165 VGND VGND VPWR VPWR sky130_fd_sc_hd__decap_3
XFILLER_42_102 VGND VGND VPWR VPWR sky130_fd_sc_hd__decap_3
XFILLER_70_433 VGND VGND VPWR VPWR sky130_fd_sc_hd__fill_2
XFILLER_15_349 VPWR VGND VPWR VGND sky130_ef_sc_hd__decap_12
XFILLER_35_55 VGND VGND VPWR VPWR sky130_fd_sc_hd__fill_1
XFILLER_70_488 VPWR VGND VPWR VGND sky130_ef_sc_hd__decap_12
XFILLER_70_477 VGND VGND VPWR VPWR sky130_fd_sc_hd__fill_1
XFILLER_35_99 VGND VGND VPWR VPWR sky130_fd_sc_hd__fill_1
XFILLER_42_146 VGND VGND VPWR VPWR sky130_fd_sc_hd__decap_3
XFILLER_51_21 VPWR VGND VPWR VGND sky130_ef_sc_hd__decap_12
XFILLER_51_691 VGND VGND VPWR VPWR sky130_fd_sc_hd__fill_1
XFILLER_51_54 VGND VGND VPWR VPWR sky130_fd_sc_hd__fill_2
XFILLER_7_559 VGND VGND VPWR VPWR sky130_fd_sc_hd__fill_1
XTAP_TAPCELL_ROW_94_1379 VGND VPWR sky130_fd_sc_hd__tapvpwrvgnd_1
XFILLER_105_671 VGND VGND VPWR VPWR sky130_fd_sc_hd__fill_1
XFILLER_2_253 VGND VGND VPWR VPWR sky130_fd_sc_hd__fill_2
XFILLER_104_170 VGND VGND VPWR VPWR sky130_fd_sc_hd__decap_3
XFILLER_78_533 VPWR VGND VPWR VGND sky130_ef_sc_hd__decap_12
XFILLER_2_286 VGND VGND VPWR VPWR sky130_fd_sc_hd__fill_2
XFILLER_38_408 VPWR VGND VPWR VGND sky130_ef_sc_hd__decap_12
XFILLER_93_547 VGND VGND VPWR VPWR sky130_fd_sc_hd__fill_1
XFILLER_93_569 VPWR VGND VPWR VGND sky130_ef_sc_hd__decap_12
XFILLER_18_165 VPWR VGND VPWR VGND sky130_ef_sc_hd__decap_12
XFILLER_34_625 VPWR VGND VPWR VGND sky130_ef_sc_hd__decap_12
XFILLER_92_72 VPWR VGND VPWR VGND sky130_ef_sc_hd__decap_12
XFILLER_33_113 VGND VGND VPWR VPWR sky130_fd_sc_hd__decap_8
XFILLER_34_669 VPWR VGND VPWR VGND sky130_ef_sc_hd__decap_12
XFILLER_33_157 VGND VGND VPWR VPWR sky130_fd_sc_hd__decap_8
XTAP_TAPCELL_ROW_103_1486 VGND VPWR sky130_fd_sc_hd__tapvpwrvgnd_1
X_4670_ _0419_ _0430_ VGND VGND VPWR VPWR _0432_ sky130_fd_sc_hd__xor2_1
XFILLER_14_393 VPWR VGND VPWR VGND sky130_ef_sc_hd__decap_12
X_3621_ _2822_ _2824_ net244 VGND VGND VPWR VPWR _2825_ sky130_fd_sc_hd__mux2_1
X_3552_ _2303_ _2357_ net250 VGND VGND VPWR VPWR _2368_ sky130_fd_sc_hd__mux2_1
X_6340_ _2216_ _2217_ _2054_ _2056_ VGND VGND VPWR VPWR _2219_ sky130_fd_sc_hd__o211a_1
XFILLER_6_581 VGND VGND VPWR VPWR sky130_fd_sc_hd__decap_6
X_3483_ net155 _1604_ VGND VGND VPWR VPWR _1615_ sky130_fd_sc_hd__nand2_1
X_6271_ _1977_ _1979_ _2142_ _2143_ VGND VGND VPWR VPWR _2144_ sky130_fd_sc_hd__a211oi_4
X_5222_ net282 net466 VGND VGND VPWR VPWR _0999_ sky130_fd_sc_hd__nand2_1
X_5153_ _0920_ _0922_ _0856_ _0859_ VGND VGND VPWR VPWR _0924_ sky130_fd_sc_hd__o211ai_2
XFILLER_69_533 VGND VGND VPWR VPWR sky130_fd_sc_hd__fill_1
XFILLER_111_641 VPWR VGND VPWR VGND sky130_ef_sc_hd__decap_12
XFILLER_96_363 VGND VGND VPWR VPWR sky130_fd_sc_hd__fill_1
XFILLER_29_419 VGND VGND VPWR VPWR sky130_fd_sc_hd__fill_2
X_4104_ net448 net274 _3228_ _3225_ VGND VGND VPWR VPWR _3287_ sky130_fd_sc_hd__a31o_1
XFILLER_111_685 VGND VGND VPWR VPWR sky130_fd_sc_hd__decap_6
X_5084_ _0751_ _0754_ VGND VGND VPWR VPWR _0849_ sky130_fd_sc_hd__nand2_1
X_4035_ _2863_ _3135_ VGND VGND VPWR VPWR _3222_ sky130_fd_sc_hd__or2_1
XTAP_TAPCELL_ROW_55_907 VGND VPWR sky130_fd_sc_hd__tapvpwrvgnd_1
XFILLER_112_27 VGND VGND VPWR VPWR sky130_fd_sc_hd__fill_1
XTAP_TAPCELL_ROW_69_1083 VGND VPWR sky130_fd_sc_hd__tapvpwrvgnd_1
XFILLER_52_433 VGND VGND VPWR VPWR sky130_fd_sc_hd__fill_1
XFILLER_52_477 VGND VGND VPWR VPWR sky130_fd_sc_hd__decap_3
X_5986_ _1684_ _1686_ _1831_ _1832_ VGND VGND VPWR VPWR _1833_ sky130_fd_sc_hd__a211oi_4
X_4937_ _0694_ _0695_ VGND VGND VPWR VPWR _0696_ sky130_fd_sc_hd__and2b_1
XFILLER_12_319 VPWR VGND VPWR VGND sky130_ef_sc_hd__decap_12
XFILLER_33_691 VGND VGND VPWR VPWR sky130_fd_sc_hd__fill_1
XTAP_TAPCELL_ROW_35_675 VGND VPWR sky130_fd_sc_hd__tapvpwrvgnd_1
X_4868_ net393 net189 net344 net401 VGND VGND VPWR VPWR _0627_ sky130_fd_sc_hd__a22o_1
XANTENNA_20 net44 VGND VGND VPWR VPWR sky130_fd_sc_hd__diode_2
XANTENNA_31 net366 VGND VGND VPWR VPWR sky130_fd_sc_hd__diode_2
X_3819_ net143 _3003_ _3014_ net136 VGND VGND VPWR VPWR _3015_ sky130_fd_sc_hd__o211a_1
X_6607_ net413 net254 _2338_ _2337_ VGND VGND VPWR VPWR _2510_ sky130_fd_sc_hd__a31o_1
XANTENNA_42 net320 VGND VGND VPWR VPWR sky130_fd_sc_hd__diode_2
X_4799_ _0543_ _0558_ VGND VGND VPWR VPWR _0559_ sky130_fd_sc_hd__or2_1
XFILLER_21_57 VPWR VGND VPWR VGND sky130_ef_sc_hd__decap_12
X_6538_ _2433_ _2435_ VGND VGND VPWR VPWR _2436_ sky130_fd_sc_hd__nor2_1
X_6469_ net430 net382 net296 net292 VGND VGND VPWR VPWR _2360_ sky130_fd_sc_hd__and4_1
XFILLER_97_39 VPWR VGND VPWR VGND sky130_ef_sc_hd__decap_12
XTAP_TAPCELL_ROW_7_334 VGND VPWR sky130_fd_sc_hd__tapvpwrvgnd_1
XPHY_EDGE_ROW_102_Right_102 VGND VGND VPWR VPWR sky130_fd_sc_hd__decap_3
XFILLER_75_503 VGND VGND VPWR VPWR sky130_fd_sc_hd__fill_1
XFILLER_87_385 VGND VGND VPWR VPWR sky130_fd_sc_hd__decap_6
XFILLER_16_625 VPWR VGND VPWR VGND sky130_ef_sc_hd__decap_12
XFILLER_55_293 VGND VGND VPWR VPWR sky130_fd_sc_hd__decap_6
XFILLER_15_135 VGND VGND VPWR VPWR sky130_fd_sc_hd__decap_8
XFILLER_16_669 VPWR VGND VPWR VGND sky130_ef_sc_hd__decap_12
XFILLER_31_617 VPWR VGND VPWR VGND sky130_ef_sc_hd__decap_12
XTAP_TAPCELL_ROW_96_1408 VGND VPWR sky130_fd_sc_hd__tapvpwrvgnd_1
XFILLER_7_15 VPWR VGND VPWR VGND sky130_ef_sc_hd__decap_12
XFILLER_3_573 VPWR VGND VPWR VGND sky130_ef_sc_hd__decap_12
XFILLER_97_149 VPWR VGND VPWR VGND sky130_ef_sc_hd__decap_12
XFILLER_87_72 VGND VGND VPWR VPWR sky130_fd_sc_hd__decap_3
XFILLER_78_330 VGND VGND VPWR VPWR sky130_fd_sc_hd__fill_1
XFILLER_78_374 VPWR VGND VPWR VGND sky130_ef_sc_hd__decap_12
XFILLER_38_216 VPWR VGND VPWR VGND sky130_ef_sc_hd__decap_12
XFILLER_38_249 VGND VGND VPWR VPWR sky130_fd_sc_hd__decap_3
XFILLER_81_517 VGND VGND VPWR VPWR sky130_fd_sc_hd__decap_6
XTAP_TAPCELL_ROW_105_1515 VGND VPWR sky130_fd_sc_hd__tapvpwrvgnd_1
XFILLER_46_271 VGND VGND VPWR VPWR sky130_fd_sc_hd__decap_8
XFILLER_46_282 VGND VGND VPWR VPWR sky130_fd_sc_hd__decap_4
XFILLER_34_455 VPWR VGND VPWR VGND sky130_ef_sc_hd__decap_12
XFILLER_34_477 VGND VGND VPWR VPWR sky130_fd_sc_hd__decap_4
X_5840_ _2095_ _1672_ VGND VGND VPWR VPWR _1674_ sky130_fd_sc_hd__xor2_2
X_5771_ _1595_ _1596_ VGND VGND VPWR VPWR _1598_ sky130_fd_sc_hd__xnor2_1
XFILLER_21_105 VGND VGND VPWR VPWR sky130_fd_sc_hd__decap_6
XFILLER_34_499 VGND VGND VPWR VPWR sky130_fd_sc_hd__decap_4
X_4722_ _0481_ _0482_ _0480_ VGND VGND VPWR VPWR _0483_ sky130_fd_sc_hd__a21o_1
XTAP_TAPCELL_ROW_32_634 VGND VPWR sky130_fd_sc_hd__tapvpwrvgnd_1
XTAP_TAPCELL_ROW_60_976 VGND VPWR sky130_fd_sc_hd__tapvpwrvgnd_1
X_4653_ net474 net458 net338 net334 VGND VGND VPWR VPWR _0415_ sky130_fd_sc_hd__and4_1
Xinput40 b[16] VGND VGND VPWR VPWR net40 sky130_fd_sc_hd__clkbuf_4
Xinput62 b[7] VGND VGND VPWR VPWR net62 sky130_fd_sc_hd__clkbuf_2
X_4584_ net417 net194 VGND VGND VPWR VPWR _0347_ sky130_fd_sc_hd__nand2_1
X_3604_ _2806_ _2807_ VGND VGND VPWR VPWR _2808_ sky130_fd_sc_hd__nand2_1
Xinput73 opcode[7] VGND VGND VPWR VPWR net73 sky130_fd_sc_hd__clkbuf_1
XTAP_TAPCELL_ROW_12_391 VGND VPWR sky130_fd_sc_hd__tapvpwrvgnd_1
Xinput51 b[26] VGND VGND VPWR VPWR net51 sky130_fd_sc_hd__clkbuf_1
XTAP_TAPCELL_ROW_116_1655 VGND VPWR sky130_fd_sc_hd__tapvpwrvgnd_1
XTAP_TAPCELL_ROW_116_1644 VGND VPWR sky130_fd_sc_hd__tapvpwrvgnd_1
X_6323_ _2198_ _2199_ VGND VGND VPWR VPWR _2200_ sky130_fd_sc_hd__nor2_1
X_3535_ net346 _0895_ _2172_ VGND VGND VPWR VPWR _2182_ sky130_fd_sc_hd__o21a_1
XFILLER_107_27 VPWR VGND VPWR VGND sky130_ef_sc_hd__decap_12
XFILLER_103_405 VPWR VGND VPWR VGND sky130_ef_sc_hd__decap_12
XFILLER_89_617 VPWR VGND VPWR VGND sky130_ef_sc_hd__decap_12
X_6254_ _1956_ _1958_ _2123_ VGND VGND VPWR VPWR _2125_ sky130_fd_sc_hd__nand3_1
X_3466_ net347 net428 VGND VGND VPWR VPWR _1430_ sky130_fd_sc_hd__nand2_2
XFILLER_103_449 VGND VGND VPWR VPWR sky130_fd_sc_hd__decap_8
XFILLER_88_149 VPWR VGND VPWR VGND sky130_ef_sc_hd__decap_12
X_5205_ _0977_ _0978_ _0873_ VGND VGND VPWR VPWR _0981_ sky130_fd_sc_hd__a21oi_1
XFILLER_57_503 VGND VGND VPWR VPWR sky130_fd_sc_hd__fill_1
XTAP_TAPCELL_ROW_4_304 VGND VPWR sky130_fd_sc_hd__tapvpwrvgnd_1
X_6185_ _2046_ _2047_ net374 net274 VGND VGND VPWR VPWR _2049_ sky130_fd_sc_hd__and4b_1
XFILLER_96_171 VPWR VGND VPWR VGND sky130_ef_sc_hd__decap_12
XFILLER_96_160 VGND VGND VPWR VPWR sky130_fd_sc_hd__fill_2
X_5136_ _2018_ _0904_ VGND VGND VPWR VPWR _0905_ sky130_fd_sc_hd__nand2b_1
XFILLER_29_205 VGND VGND VPWR VPWR sky130_fd_sc_hd__decap_3
XFILLER_84_355 VGND VGND VPWR VPWR sky130_fd_sc_hd__decap_8
XFILLER_84_344 VGND VGND VPWR VPWR sky130_fd_sc_hd__fill_1
X_5067_ _0733_ _0741_ _0740_ VGND VGND VPWR VPWR _0831_ sky130_fd_sc_hd__o21ba_1
XFILLER_84_377 VGND VGND VPWR VPWR sky130_fd_sc_hd__decap_6
X_4018_ _3200_ _3204_ VGND VGND VPWR VPWR _3205_ sky130_fd_sc_hd__nand2_1
XFILLER_37_293 VPWR VGND VPWR VGND sky130_ef_sc_hd__decap_12
XTAP_TAPCELL_ROW_80_1209 VGND VPWR sky130_fd_sc_hd__tapvpwrvgnd_1
XFILLER_13_617 VPWR VGND VPWR VGND sky130_ef_sc_hd__decap_12
XFILLER_52_241 VGND VGND VPWR VPWR sky130_fd_sc_hd__decap_8
X_5969_ _1811_ _1813_ VGND VGND VPWR VPWR _1815_ sky130_fd_sc_hd__xnor2_1
XFILLER_40_469 VGND VGND VPWR VPWR sky130_fd_sc_hd__fill_1
XFILLER_32_89 VGND VGND VPWR VPWR sky130_fd_sc_hd__fill_1
XFILLER_106_232 VPWR VGND VPWR VGND sky130_ef_sc_hd__decap_12
XFILLER_4_337 VPWR VGND VPWR VGND sky130_ef_sc_hd__decap_12
XFILLER_106_265 VPWR VGND VPWR VGND sky130_ef_sc_hd__decap_12
XTAP_TAPCELL_ROW_91_1338 VGND VPWR sky130_fd_sc_hd__tapvpwrvgnd_1
XTAP_TAPCELL_ROW_91_1349 VGND VPWR sky130_fd_sc_hd__tapvpwrvgnd_1
XFILLER_95_609 VGND VGND VPWR VPWR sky130_fd_sc_hd__decap_6
XFILLER_48_525 VGND VGND VPWR VPWR sky130_fd_sc_hd__decap_6
XFILLER_75_388 VGND VGND VPWR VPWR sky130_fd_sc_hd__decap_4
XFILLER_35_208 VPWR VGND VPWR VGND sky130_ef_sc_hd__decap_12
XFILLER_113_81 VPWR VGND VPWR VGND sky130_ef_sc_hd__decap_12
XFILLER_16_411 VGND VGND VPWR VPWR sky130_fd_sc_hd__fill_1
XFILLER_28_293 VGND VGND VPWR VPWR sky130_fd_sc_hd__decap_8
XFILLER_90_358 VGND VGND VPWR VPWR sky130_fd_sc_hd__decap_6
XFILLER_16_499 VPWR VGND VPWR VGND sky130_ef_sc_hd__decap_12
XFILLER_31_458 VGND VGND VPWR VPWR sky130_fd_sc_hd__decap_8
XTAP_TAPCELL_ROW_100_1456 VGND VPWR sky130_fd_sc_hd__tapvpwrvgnd_1
XFILLER_8_643 VGND VGND VPWR VPWR sky130_fd_sc_hd__fill_1
XFILLER_7_120 VPWR VGND VPWR VGND sky130_ef_sc_hd__decap_12
XFILLER_112_213 VGND VGND VPWR VPWR sky130_fd_sc_hd__decap_8
XFILLER_98_436 VGND VGND VPWR VPWR sky130_fd_sc_hd__decap_8
XFILLER_3_381 VGND VGND VPWR VPWR sky130_fd_sc_hd__decap_8
XTAP_TAPCELL_ROW_111_1585 VGND VPWR sky130_fd_sc_hd__tapvpwrvgnd_1
XFILLER_21_3 VPWR VGND VPWR VGND sky130_ef_sc_hd__decap_12
XFILLER_39_525 VPWR VGND VPWR VGND sky130_ef_sc_hd__decap_12
XFILLER_66_377 VPWR VGND VPWR VGND sky130_ef_sc_hd__decap_12
XFILLER_66_355 VGND VGND VPWR VPWR sky130_fd_sc_hd__decap_3
XFILLER_19_271 VGND VGND VPWR VPWR sky130_fd_sc_hd__decap_8
XFILLER_19_293 VGND VGND VPWR VPWR sky130_fd_sc_hd__decap_8
XTAP_TAPCELL_ROW_66_1042 VGND VPWR sky130_fd_sc_hd__tapvpwrvgnd_1
X_6872_ net179 _1102_ _0000_ net67 VGND VGND VPWR VPWR _0002_ sky130_fd_sc_hd__and4b_1
XTAP_TAPCELL_ROW_17_450 VGND VPWR sky130_fd_sc_hd__tapvpwrvgnd_1
XTAP_TAPCELL_ROW_17_461 VGND VPWR sky130_fd_sc_hd__tapvpwrvgnd_1
X_5823_ _1613_ _1652_ _1653_ VGND VGND VPWR VPWR _1655_ sky130_fd_sc_hd__nand3_2
XTAP_TAPCELL_ROW_45_792 VGND VPWR sky130_fd_sc_hd__tapvpwrvgnd_1
X_5754_ _1578_ _1579_ _1447_ _1450_ VGND VGND VPWR VPWR _1580_ sky130_fd_sc_hd__o211a_1
X_4705_ _0366_ _0369_ _0463_ _0465_ VGND VGND VPWR VPWR _0467_ sky130_fd_sc_hd__a211o_1
X_5685_ net360 net322 _1502_ _1503_ VGND VGND VPWR VPWR _1504_ sky130_fd_sc_hd__nand4_1
X_4636_ _0395_ _0396_ _0329_ _0332_ VGND VGND VPWR VPWR _0399_ sky130_fd_sc_hd__o211a_1
XPHY_EDGE_ROW_62_Left_179 VGND VGND VPWR VPWR sky130_fd_sc_hd__decap_3
X_4567_ _0329_ _0330_ _0269_ VGND VGND VPWR VPWR _0331_ sky130_fd_sc_hd__a21bo_1
XTAP_TAPCELL_ROW_77_1171 VGND VPWR sky130_fd_sc_hd__tapvpwrvgnd_1
X_6306_ net405 net266 _2024_ _2022_ VGND VGND VPWR VPWR _2181_ sky130_fd_sc_hd__a31o_1
XFILLER_116_596 VGND VGND VPWR VPWR sky130_fd_sc_hd__decap_8
X_4498_ _0194_ _0262_ VGND VGND VPWR VPWR _0263_ sky130_fd_sc_hd__nand2b_1
X_3518_ net137 _1844_ _1855_ net144 _1986_ VGND VGND VPWR VPWR _1997_ sky130_fd_sc_hd__a221o_1
XFILLER_103_246 VGND VGND VPWR VPWR sky130_fd_sc_hd__decap_8
X_3449_ _1048_ _1124_ VGND VGND VPWR VPWR _1244_ sky130_fd_sc_hd__nor2_1
X_6237_ _2103_ _2104_ _1934_ _1936_ VGND VGND VPWR VPWR _2107_ sky130_fd_sc_hd__o211a_1
XFILLER_103_279 VGND VGND VPWR VPWR sky130_fd_sc_hd__fill_1
X_6168_ _2019_ _2021_ _2030_ VGND VGND VPWR VPWR _2031_ sky130_fd_sc_hd__and3_1
X_5119_ _0700_ _0701_ _0791_ _0789_ VGND VGND VPWR VPWR _0888_ sky130_fd_sc_hd__o31a_1
XFILLER_94_29 VPWR VGND VPWR VGND sky130_ef_sc_hd__decap_12
XFILLER_85_653 VPWR VGND VPWR VGND sky130_ef_sc_hd__decap_12
XFILLER_69_182 VGND VGND VPWR VPWR sky130_fd_sc_hd__decap_8
XFILLER_84_141 VPWR VGND VPWR VGND sky130_ef_sc_hd__decap_12
XPHY_EDGE_ROW_71_Left_188 VGND VGND VPWR VPWR sky130_fd_sc_hd__decap_3
X_6099_ _1954_ _1955_ VGND VGND VPWR VPWR _1956_ sky130_fd_sc_hd__nand2_1
XFILLER_53_583 VPWR VGND VPWR VGND sky130_ef_sc_hd__decap_12
XFILLER_43_55 VGND VGND VPWR VPWR sky130_fd_sc_hd__fill_1
XFILLER_43_77 VGND VGND VPWR VPWR sky130_fd_sc_hd__decap_3
XPHY_EDGE_ROW_80_Left_197 VGND VGND VPWR VPWR sky130_fd_sc_hd__decap_3
XFILLER_107_585 VPWR VGND VPWR VGND sky130_ef_sc_hd__decap_12
XFILLER_4_189 VGND VGND VPWR VPWR sky130_fd_sc_hd__decap_6
XFILLER_4_27 VGND VGND VPWR VPWR sky130_fd_sc_hd__fill_1
XFILLER_95_406 VGND VGND VPWR VPWR sky130_fd_sc_hd__decap_3
XFILLER_68_41 VPWR VGND VPWR VGND sky130_ef_sc_hd__decap_12
XFILLER_95_417 VGND VGND VPWR VPWR sky130_fd_sc_hd__fill_1
XFILLER_76_631 VPWR VGND VPWR VGND sky130_ef_sc_hd__decap_12
XFILLER_84_62 VGND VGND VPWR VPWR sky130_fd_sc_hd__fill_1
XFILLER_84_51 VGND VGND VPWR VPWR sky130_fd_sc_hd__decap_4
XFILLER_36_528 VGND VGND VPWR VPWR sky130_fd_sc_hd__decap_4
XFILLER_63_369 VGND VGND VPWR VPWR sky130_fd_sc_hd__decap_4
XFILLER_90_188 VGND VGND VPWR VPWR sky130_fd_sc_hd__decap_8
XFILLER_44_583 VGND VGND VPWR VPWR sky130_fd_sc_hd__decap_4
XTAP_TAPCELL_ROW_14_420 VGND VPWR sky130_fd_sc_hd__tapvpwrvgnd_1
XTAP_TAPCELL_ROW_42_751 VGND VPWR sky130_fd_sc_hd__tapvpwrvgnd_1
X_5470_ _1262_ _1268_ VGND VGND VPWR VPWR _1270_ sky130_fd_sc_hd__xnor2_1
X_4421_ _0160_ _0170_ _0172_ VGND VGND VPWR VPWR _0187_ sky130_fd_sc_hd__a21oi_1
XTAP_TAPCELL_ROW_113_1603 VGND VPWR sky130_fd_sc_hd__tapvpwrvgnd_1
X_4352_ net471 net454 net214 net208 VGND VGND VPWR VPWR _0120_ sky130_fd_sc_hd__and4_1
X_4283_ _0047_ _0053_ net148 VGND VGND VPWR VPWR _0055_ sky130_fd_sc_hd__o21a_1
Xfanout408 net410 VGND VGND VPWR VPWR net408 sky130_fd_sc_hd__clkbuf_4
Xfanout419 net421 VGND VGND VPWR VPWR net419 sky130_fd_sc_hd__buf_2
XFILLER_98_277 VGND VGND VPWR VPWR sky130_fd_sc_hd__decap_4
X_6022_ _1870_ _1869_ VGND VGND VPWR VPWR _1871_ sky130_fd_sc_hd__and2b_1
XFILLER_79_480 VGND VGND VPWR VPWR sky130_fd_sc_hd__fill_1
XFILLER_39_311 VGND VGND VPWR VPWR sky130_fd_sc_hd__decap_3
XFILLER_82_601 VPWR VGND VPWR VGND sky130_ef_sc_hd__decap_12
XFILLER_66_141 VPWR VGND VPWR VGND sky130_ef_sc_hd__decap_12
XFILLER_39_377 VPWR VGND VPWR VGND sky130_ef_sc_hd__decap_12
XFILLER_82_645 VPWR VGND VPWR VGND sky130_ef_sc_hd__decap_12
XFILLER_54_325 VPWR VGND VPWR VGND sky130_ef_sc_hd__decap_12
XFILLER_27_528 VGND VGND VPWR VPWR sky130_fd_sc_hd__fill_1
XFILLER_82_689 VGND VGND VPWR VPWR sky130_fd_sc_hd__decap_3
XFILLER_35_572 VGND VGND VPWR VPWR sky130_fd_sc_hd__decap_8
X_6855_ _2554_ _2594_ _2552_ VGND VGND VPWR VPWR _2781_ sky130_fd_sc_hd__a21bo_1
XFILLER_35_594 VPWR VGND VPWR VGND sky130_ef_sc_hd__decap_12
XFILLER_50_531 VGND VGND VPWR VPWR sky130_fd_sc_hd__fill_1
X_5806_ _1632_ _1633_ _1634_ VGND VGND VPWR VPWR _1636_ sky130_fd_sc_hd__a21bo_1
X_6786_ _2495_ _2704_ VGND VGND VPWR VPWR _2705_ sky130_fd_sc_hd__xnor2_1
X_3998_ _3161_ _3165_ VGND VGND VPWR VPWR _3186_ sky130_fd_sc_hd__nand2_1
XTAP_TAPCELL_ROW_79_1200 VGND VPWR sky130_fd_sc_hd__tapvpwrvgnd_1
X_5737_ _1559_ _1560_ _1542_ VGND VGND VPWR VPWR _1562_ sky130_fd_sc_hd__a21o_1
XFILLER_13_69 VGND VGND VPWR VPWR sky130_fd_sc_hd__decap_8
XTAP_TAPCELL_ROW_20_489 VGND VPWR sky130_fd_sc_hd__tapvpwrvgnd_1
X_5668_ _1483_ _1485_ VGND VGND VPWR VPWR _1486_ sky130_fd_sc_hd__and2b_1
X_4619_ _0379_ _0380_ _0370_ VGND VGND VPWR VPWR _0382_ sky130_fd_sc_hd__a21o_1
X_5599_ _1409_ _1410_ VGND VGND VPWR VPWR _1411_ sky130_fd_sc_hd__nand2b_1
XFILLER_116_382 VGND VGND VPWR VPWR sky130_fd_sc_hd__fill_1
XFILLER_89_222 VGND VGND VPWR VPWR sky130_fd_sc_hd__fill_2
XFILLER_104_533 VPWR VGND VPWR VGND sky130_ef_sc_hd__decap_12
XFILLER_1_126 VGND VGND VPWR VPWR sky130_fd_sc_hd__decap_4
XFILLER_18_506 VPWR VGND VPWR VGND sky130_ef_sc_hd__decap_12
XFILLER_57_196 VGND VGND VPWR VPWR sky130_fd_sc_hd__decap_8
XFILLER_45_325 VGND VGND VPWR VPWR sky130_fd_sc_hd__decap_4
XTAP_TAPCELL_ROW_28_589 VGND VPWR sky130_fd_sc_hd__tapvpwrvgnd_1
XPHY_EDGE_ROW_109_Left_226 VGND VGND VPWR VPWR sky130_fd_sc_hd__decap_3
XFILLER_54_76 VGND VGND VPWR VPWR sky130_fd_sc_hd__decap_8
XFILLER_9_215 VGND VGND VPWR VPWR sky130_fd_sc_hd__decap_8
XFILLER_79_51 VGND VGND VPWR VPWR sky130_fd_sc_hd__decap_4
XFILLER_107_393 VPWR VGND VPWR VGND sky130_ef_sc_hd__decap_12
XFILLER_79_84 VPWR VGND VPWR VGND sky130_ef_sc_hd__decap_12
XFILLER_110_525 VGND VGND VPWR VPWR sky130_fd_sc_hd__decap_6
XFILLER_68_406 VGND VGND VPWR VPWR sky130_fd_sc_hd__decap_8
XFILLER_1_671 VGND VGND VPWR VPWR sky130_fd_sc_hd__fill_1
XFILLER_95_225 VPWR VGND VPWR VGND sky130_ef_sc_hd__decap_12
XFILLER_110_569 VPWR VGND VPWR VGND sky130_ef_sc_hd__decap_12
XFILLER_95_269 VGND VGND VPWR VPWR sky130_fd_sc_hd__fill_1
XFILLER_64_601 VPWR VGND VPWR VGND sky130_ef_sc_hd__decap_12
XFILLER_49_653 VPWR VGND VPWR VGND sky130_ef_sc_hd__decap_12
XFILLER_64_645 VPWR VGND VPWR VGND sky130_ef_sc_hd__decap_12
XFILLER_63_111 VGND VGND VPWR VPWR sky130_fd_sc_hd__fill_1
XTAP_TAPCELL_ROW_47_810 VGND VPWR sky130_fd_sc_hd__tapvpwrvgnd_1
XTAP_TAPCELL_ROW_47_821 VGND VPWR sky130_fd_sc_hd__tapvpwrvgnd_1
XFILLER_48_185 VGND VGND VPWR VPWR sky130_fd_sc_hd__decap_8
XFILLER_91_464 VGND VGND VPWR VPWR sky130_fd_sc_hd__fill_1
XFILLER_91_431 VPWR VGND VPWR VGND sky130_ef_sc_hd__decap_12
X_4970_ _0726_ _0727_ VGND VGND VPWR VPWR _0728_ sky130_fd_sc_hd__nand2_1
XFILLER_64_689 VGND VGND VPWR VPWR sky130_fd_sc_hd__decap_3
XFILLER_17_561 VGND VGND VPWR VPWR sky130_fd_sc_hd__decap_8
XTAP_TAPCELL_ROW_63_1012 VGND VPWR sky130_fd_sc_hd__tapvpwrvgnd_1
X_3921_ net143 _3111_ net135 VGND VGND VPWR VPWR _3112_ sky130_fd_sc_hd__o21ai_1
XFILLER_17_594 VPWR VGND VPWR VGND sky130_ef_sc_hd__decap_12
X_3852_ _2858_ _2959_ _3046_ net118 VGND VGND VPWR VPWR _3047_ sky130_fd_sc_hd__a22o_1
X_6640_ _2544_ _2545_ VGND VGND VPWR VPWR _2546_ sky130_fd_sc_hd__nor2_1
X_6571_ _2468_ _2470_ _2449_ VGND VGND VPWR VPWR _2472_ sky130_fd_sc_hd__a21oi_1
XFILLER_32_586 VGND VGND VPWR VPWR sky130_fd_sc_hd__fill_2
X_3783_ net145 _2963_ _2971_ _2980_ VGND VGND VPWR VPWR _alu_i0.Datapath_i.fu_alu_33673_33851.out1\[9\]
+ sky130_fd_sc_hd__a211o_1
X_5522_ _1324_ _1325_ _1197_ _1199_ VGND VGND VPWR VPWR _1327_ sky130_fd_sc_hd__o211ai_2
XFILLER_105_308 VGND VGND VPWR VPWR sky130_fd_sc_hd__decap_6
X_5453_ _1247_ _1248_ _1130_ _1132_ VGND VGND VPWR VPWR _1251_ sky130_fd_sc_hd__a211o_1
XFILLER_8_292 VGND VGND VPWR VPWR sky130_fd_sc_hd__fill_2
X_4404_ _0160_ _0170_ VGND VGND VPWR VPWR _0171_ sky130_fd_sc_hd__xor2_1
X_5384_ net315 _1174_ _1173_ VGND VGND VPWR VPWR _1176_ sky130_fd_sc_hd__a21bo_1
XFILLER_99_553 VGND VGND VPWR VPWR sky130_fd_sc_hd__decap_6
X_4335_ _0102_ _0103_ VGND VGND VPWR VPWR _0104_ sky130_fd_sc_hd__nand2_1
XTAP_TAPCELL_ROW_74_1141 VGND VPWR sky130_fd_sc_hd__tapvpwrvgnd_1
Xfanout205 net207 VGND VGND VPWR VPWR net205 sky130_fd_sc_hd__buf_2
XFILLER_115_27 VPWR VGND VPWR VGND sky130_ef_sc_hd__decap_12
Xfanout238 net239 VGND VGND VPWR VPWR net238 sky130_fd_sc_hd__buf_2
Xfanout216 net217 VGND VGND VPWR VPWR net216 sky130_fd_sc_hd__clkbuf_2
XFILLER_99_597 VPWR VGND VPWR VGND sky130_ef_sc_hd__decap_12
Xfanout227 net228 VGND VGND VPWR VPWR net227 sky130_fd_sc_hd__buf_2
XFILLER_59_417 VPWR VGND VPWR VGND sky130_ef_sc_hd__decap_12
Xfanout249 net250 VGND VGND VPWR VPWR net249 sky130_fd_sc_hd__buf_2
XFILLER_101_558 VGND VGND VPWR VPWR sky130_fd_sc_hd__fill_2
XFILLER_101_525 VGND VGND VPWR VPWR sky130_fd_sc_hd__fill_1
X_4266_ net128 _0031_ VGND VGND VPWR VPWR _0041_ sky130_fd_sc_hd__nor2_1
XFILLER_67_461 VGND VGND VPWR VPWR sky130_fd_sc_hd__decap_3
XFILLER_39_152 VPWR VGND VPWR VGND sky130_ef_sc_hd__decap_12
X_4197_ _3353_ _3375_ VGND VGND VPWR VPWR _3376_ sky130_fd_sc_hd__nand2_1
X_6005_ _1707_ _1709_ _1851_ _1852_ VGND VGND VPWR VPWR _1853_ sky130_fd_sc_hd__a211oi_2
XFILLER_27_369 VPWR VGND VPWR VGND sky130_ef_sc_hd__decap_12
XFILLER_42_306 VGND VGND VPWR VPWR sky130_fd_sc_hd__fill_2
XTAP_TAPCELL_ROW_85_1270 VGND VPWR sky130_fd_sc_hd__tapvpwrvgnd_1
X_6907_ net180 _0001_ VGND VGND VPWR VPWR _alu_i0.Controller_i._present_state\[0\]
+ sky130_fd_sc_hd__dfxtp_1
XTAP_TAPCELL_ROW_25_548 VGND VPWR sky130_fd_sc_hd__tapvpwrvgnd_1
XFILLER_35_391 VGND VGND VPWR VPWR sky130_fd_sc_hd__fill_1
XFILLER_23_575 VPWR VGND VPWR VGND sky130_ef_sc_hd__decap_12
X_6838_ net219 net306 _3095_ _2579_ VGND VGND VPWR VPWR _2763_ sky130_fd_sc_hd__a31o_1
XFILLER_50_361 VGND VGND VPWR VPWR sky130_fd_sc_hd__decap_3
XFILLER_10_214 VPWR VGND VPWR VGND sky130_ef_sc_hd__decap_12
X_6769_ net437 net213 _2624_ _2623_ VGND VGND VPWR VPWR _2687_ sky130_fd_sc_hd__a31o_1
XFILLER_2_446 VPWR VGND VPWR VGND sky130_ef_sc_hd__decap_12
XFILLER_49_21 VPWR VGND VPWR VGND sky130_ef_sc_hd__decap_12
XFILLER_77_225 VPWR VGND VPWR VGND sky130_ef_sc_hd__decap_12
XFILLER_105_93 VGND VGND VPWR VPWR sky130_fd_sc_hd__decap_3
XFILLER_1_39 VPWR VGND VPWR VGND sky130_ef_sc_hd__decap_12
XFILLER_46_612 VPWR VGND VPWR VGND sky130_ef_sc_hd__decap_12
XFILLER_65_75 VGND VGND VPWR VPWR sky130_fd_sc_hd__fill_1
XFILLER_46_645 VPWR VGND VPWR VGND sky130_ef_sc_hd__decap_12
XFILLER_18_369 VGND VGND VPWR VPWR sky130_fd_sc_hd__fill_1
XFILLER_33_317 VGND VGND VPWR VPWR sky130_fd_sc_hd__decap_3
XFILLER_46_689 VGND VGND VPWR VPWR sky130_fd_sc_hd__decap_3
XFILLER_73_497 VGND VGND VPWR VPWR sky130_fd_sc_hd__fill_1
XFILLER_45_188 VPWR VGND VPWR VGND sky130_ef_sc_hd__decap_12
XFILLER_81_63 VGND VGND VPWR VPWR sky130_fd_sc_hd__decap_4
XFILLER_60_147 VGND VGND VPWR VPWR sky130_fd_sc_hd__fill_1
XFILLER_81_96 VGND VGND VPWR VPWR sky130_fd_sc_hd__fill_1
XFILLER_81_85 VGND VGND VPWR VPWR sky130_fd_sc_hd__fill_2
XTAP_TAPCELL_ROW_99_1439 VGND VPWR sky130_fd_sc_hd__tapvpwrvgnd_1
XPHY_EDGE_ROW_116_Right_116 VGND VGND VPWR VPWR sky130_fd_sc_hd__decap_3
XFILLER_115_617 VPWR VGND VPWR VGND sky130_ef_sc_hd__decap_12
XFILLER_96_512 VGND VGND VPWR VPWR sky130_fd_sc_hd__decap_8
XFILLER_110_333 VGND VGND VPWR VPWR sky130_fd_sc_hd__fill_1
X_4120_ _3291_ _3292_ _3302_ VGND VGND VPWR VPWR _3303_ sky130_fd_sc_hd__a21o_1
XFILLER_96_589 VPWR VGND VPWR VGND sky130_ef_sc_hd__decap_12
X_4051_ net135 _3227_ _3232_ _3236_ net129 VGND VGND VPWR VPWR _3237_ sky130_fd_sc_hd__o221a_1
Xinput5 a[13] VGND VGND VPWR VPWR net5 sky130_fd_sc_hd__buf_2
XFILLER_49_472 VPWR VGND VPWR VGND sky130_ef_sc_hd__decap_12
XTAP_TAPCELL_ROW_108_1546 VGND VPWR sky130_fd_sc_hd__tapvpwrvgnd_1
XFILLER_36_122 VPWR VGND VPWR VGND sky130_ef_sc_hd__decap_12
XFILLER_91_261 VGND VGND VPWR VPWR sky130_fd_sc_hd__decap_3
XFILLER_36_177 VPWR VGND VPWR VGND sky130_ef_sc_hd__decap_12
X_4953_ _0709_ _0710_ VGND VGND VPWR VPWR _0711_ sky130_fd_sc_hd__or2_1
X_3904_ net176 net316 VGND VGND VPWR VPWR _3096_ sky130_fd_sc_hd__nand2_1
XFILLER_51_169 VGND VGND VPWR VPWR sky130_fd_sc_hd__decap_6
X_4884_ _0559_ _0642_ VGND VGND VPWR VPWR _0643_ sky130_fd_sc_hd__or2_1
XFILLER_60_681 VGND VGND VPWR VPWR sky130_fd_sc_hd__decap_8
X_6623_ net310 net296 net292 net382 VGND VGND VPWR VPWR _2527_ sky130_fd_sc_hd__a22o_1
XTAP_TAPCELL_ROW_22_518 VGND VPWR sky130_fd_sc_hd__tapvpwrvgnd_1
XTAP_TAPCELL_ROW_50_849 VGND VPWR sky130_fd_sc_hd__tapvpwrvgnd_1
X_3835_ _3027_ _3029_ VGND VGND VPWR VPWR _3030_ sky130_fd_sc_hd__nand2_1
XFILLER_20_545 VGND VGND VPWR VPWR sky130_fd_sc_hd__decap_8
XFILLER_32_394 VGND VGND VPWR VPWR sky130_fd_sc_hd__fill_1
X_3766_ net362 net191 VGND VGND VPWR VPWR _2964_ sky130_fd_sc_hd__or2_1
XFILLER_20_589 VPWR VGND VPWR VGND sky130_ef_sc_hd__decap_12
X_6554_ net442 net440 net205 net198 VGND VGND VPWR VPWR _2453_ sky130_fd_sc_hd__and4_1
X_6485_ _2376_ VGND VGND VPWR VPWR _2377_ sky130_fd_sc_hd__inv_2
X_5505_ _1292_ _1306_ VGND VGND VPWR VPWR _1308_ sky130_fd_sc_hd__nand2_1
X_3697_ _2871_ _2895_ _2897_ VGND VGND VPWR VPWR _2898_ sky130_fd_sc_hd__and3_1
X_5436_ _1121_ _1125_ VGND VGND VPWR VPWR _1232_ sky130_fd_sc_hd__nand2_1
XFILLER_10_15 VPWR VGND VPWR VGND sky130_ef_sc_hd__decap_12
XFILLER_99_361 VPWR VGND VPWR VGND sky130_ef_sc_hd__decap_12
X_5367_ net313 net197 VGND VGND VPWR VPWR _1158_ sky130_fd_sc_hd__nand2_1
X_4318_ _0065_ _0087_ VGND VGND VPWR VPWR _0088_ sky130_fd_sc_hd__nand2_1
X_5298_ _1036_ _1038_ _1079_ _1080_ VGND VGND VPWR VPWR _1083_ sky130_fd_sc_hd__or4bb_1
XFILLER_87_556 VGND VGND VPWR VPWR sky130_fd_sc_hd__decap_4
XFILLER_59_258 VPWR VGND VPWR VGND sky130_ef_sc_hd__decap_12
X_4249_ net234 _0024_ VGND VGND VPWR VPWR _0025_ sky130_fd_sc_hd__or2_1
XFILLER_74_206 VGND VGND VPWR VPWR sky130_fd_sc_hd__fill_2
XTAP_TAPCELL_ROW_58_949 VGND VPWR sky130_fd_sc_hd__tapvpwrvgnd_1
XFILLER_19_57 VGND VGND VPWR VPWR sky130_fd_sc_hd__decap_8
XFILLER_28_601 VPWR VGND VPWR VGND sky130_ef_sc_hd__decap_12
XFILLER_28_645 VPWR VGND VPWR VGND sky130_ef_sc_hd__decap_12
XTAP_TAPCELL_ROW_2_276 VGND VPWR sky130_fd_sc_hd__tapvpwrvgnd_1
XFILLER_42_125 VGND VGND VPWR VPWR sky130_fd_sc_hd__decap_8
XFILLER_30_309 VPWR VGND VPWR VGND sky130_ef_sc_hd__decap_12
XFILLER_7_505 VPWR VGND VPWR VGND sky130_ef_sc_hd__decap_12
XFILLER_51_33 VPWR VGND VPWR VGND sky130_ef_sc_hd__decap_12
XFILLER_109_433 VPWR VGND VPWR VGND sky130_ef_sc_hd__decap_12
XFILLER_109_455 VGND VGND VPWR VPWR sky130_fd_sc_hd__decap_3
XFILLER_78_501 VPWR VGND VPWR VGND sky130_ef_sc_hd__decap_12
XFILLER_78_545 VGND VGND VPWR VPWR sky130_fd_sc_hd__fill_2
XFILLER_116_81 VGND VGND VPWR VPWR sky130_fd_sc_hd__decap_3
XFILLER_78_567 VPWR VGND VPWR VGND sky130_ef_sc_hd__decap_12
XFILLER_78_589 VPWR VGND VPWR VGND sky130_ef_sc_hd__decap_12
XFILLER_76_85 VGND VGND VPWR VPWR sky130_fd_sc_hd__decap_4
XFILLER_93_559 VGND VGND VPWR VPWR sky130_fd_sc_hd__fill_1
XFILLER_18_177 VPWR VGND VPWR VGND sky130_ef_sc_hd__decap_12
XFILLER_61_445 VGND VGND VPWR VPWR sky130_fd_sc_hd__decap_3
XFILLER_34_637 VGND VGND VPWR VPWR sky130_fd_sc_hd__decap_6
XFILLER_33_169 VPWR VGND VPWR VGND sky130_ef_sc_hd__decap_12
XTAP_TAPCELL_ROW_103_1487 VGND VPWR sky130_fd_sc_hd__tapvpwrvgnd_1
XFILLER_42_681 VGND VGND VPWR VPWR sky130_fd_sc_hd__decap_8
X_3620_ net346 net280 net25 VGND VGND VPWR VPWR _2824_ sky130_fd_sc_hd__or3b_1
X_3551_ _2325_ _2346_ net284 VGND VGND VPWR VPWR _2357_ sky130_fd_sc_hd__mux2_1
XFILLER_115_447 VGND VGND VPWR VPWR sky130_fd_sc_hd__fill_1
X_3482_ net251 _1593_ VGND VGND VPWR VPWR _1604_ sky130_fd_sc_hd__nor2_1
X_6270_ _2140_ _2141_ _2129_ VGND VGND VPWR VPWR _2143_ sky130_fd_sc_hd__a21oi_2
XFILLER_103_609 VGND VGND VPWR VPWR sky130_fd_sc_hd__decap_6
XFILLER_88_309 VGND VGND VPWR VPWR sky130_fd_sc_hd__fill_1
X_5221_ _0891_ _0900_ _0899_ VGND VGND VPWR VPWR _0998_ sky130_fd_sc_hd__o21ba_1
XTAP_TAPCELL_ROW_71_1100 VGND VPWR sky130_fd_sc_hd__tapvpwrvgnd_1
X_5152_ _0856_ _0859_ _0920_ _0922_ VGND VGND VPWR VPWR _0923_ sky130_fd_sc_hd__a211o_2
XFILLER_111_653 VPWR VGND VPWR VGND sky130_ef_sc_hd__decap_12
X_4103_ _3200_ _3247_ _3269_ VGND VGND VPWR VPWR _3286_ sky130_fd_sc_hd__and3_1
X_5083_ _0715_ _0723_ _0722_ VGND VGND VPWR VPWR _0848_ sky130_fd_sc_hd__a21o_1
XFILLER_84_515 VGND VGND VPWR VPWR sky130_fd_sc_hd__decap_3
X_4034_ net154 _3220_ VGND VGND VPWR VPWR _3221_ sky130_fd_sc_hd__and2_1
XTAP_TAPCELL_ROW_55_908 VGND VPWR sky130_fd_sc_hd__tapvpwrvgnd_1
XFILLER_52_401 VGND VGND VPWR VPWR sky130_fd_sc_hd__decap_6
XFILLER_25_615 VGND VGND VPWR VPWR sky130_fd_sc_hd__fill_1
XTAP_TAPCELL_ROW_69_1084 VGND VPWR sky130_fd_sc_hd__tapvpwrvgnd_1
XFILLER_24_125 VPWR VGND VPWR VGND sky130_ef_sc_hd__decap_12
XTAP_TAPCELL_ROW_82_1240 VGND VPWR sky130_fd_sc_hd__tapvpwrvgnd_1
X_5985_ _1829_ _1830_ _1819_ VGND VGND VPWR VPWR _1832_ sky130_fd_sc_hd__a21oi_2
XFILLER_40_607 VPWR VGND VPWR VGND sky130_ef_sc_hd__decap_12
X_4936_ _0692_ _0693_ _0609_ _0611_ VGND VGND VPWR VPWR _0695_ sky130_fd_sc_hd__o211ai_2
XTAP_TAPCELL_ROW_35_676 VGND VPWR sky130_fd_sc_hd__tapvpwrvgnd_1
X_4867_ net401 net393 net189 net344 VGND VGND VPWR VPWR _0626_ sky130_fd_sc_hd__and4_1
XANTENNA_32 net381 VGND VGND VPWR VPWR sky130_fd_sc_hd__diode_2
XANTENNA_10 opcode[2] VGND VGND VPWR VPWR sky130_fd_sc_hd__diode_2
XANTENNA_21 net173 VGND VGND VPWR VPWR sky130_fd_sc_hd__diode_2
X_3818_ _3009_ _3010_ _3011_ _3013_ net145 VGND VGND VPWR VPWR _3014_ sky130_fd_sc_hd__a221o_1
X_6606_ net390 net266 _2347_ _2345_ VGND VGND VPWR VPWR _2508_ sky130_fd_sc_hd__a31o_1
XFILLER_20_375 VGND VGND VPWR VPWR sky130_fd_sc_hd__fill_2
X_4798_ _0548_ _0557_ VGND VGND VPWR VPWR _0558_ sky130_fd_sc_hd__xnor2_1
X_6537_ net161 _0895_ _2431_ _2432_ VGND VGND VPWR VPWR _2435_ sky130_fd_sc_hd__o22a_1
X_3749_ _2945_ _2946_ _2947_ net126 VGND VGND VPWR VPWR _2948_ sky130_fd_sc_hd__o211a_1
XFILLER_21_69 VPWR VGND VPWR VGND sky130_ef_sc_hd__decap_12
X_6468_ net382 net296 net292 net430 VGND VGND VPWR VPWR _2359_ sky130_fd_sc_hd__a22oi_1
X_5419_ _alu_i0.Datapath_i.reg_0.reg_out1\[20\] _1214_ net146 VGND VGND VPWR VPWR
+ net89 sky130_fd_sc_hd__mux2_1
X_6399_ _2068_ _2070_ VGND VGND VPWR VPWR _2284_ sky130_fd_sc_hd__nor2_1
XTAP_TAPCELL_ROW_7_335 VGND VPWR sky130_fd_sc_hd__tapvpwrvgnd_1
XFILLER_75_537 VGND VGND VPWR VPWR sky130_fd_sc_hd__fill_1
XFILLER_47_206 VGND VGND VPWR VPWR sky130_fd_sc_hd__fill_1
XFILLER_55_261 VPWR VGND VPWR VGND sky130_ef_sc_hd__decap_12
XFILLER_46_44 VPWR VGND VPWR VGND sky130_ef_sc_hd__decap_12
XFILLER_16_637 VGND VGND VPWR VPWR sky130_fd_sc_hd__decap_6
XFILLER_28_486 VPWR VGND VPWR VGND sky130_ef_sc_hd__decap_12
XFILLER_62_21 VGND VGND VPWR VPWR sky130_fd_sc_hd__decap_6
XFILLER_15_169 VPWR VGND VPWR VGND sky130_ef_sc_hd__decap_12
XFILLER_43_467 VGND VGND VPWR VPWR sky130_fd_sc_hd__fill_1
XFILLER_24_681 VGND VGND VPWR VPWR sky130_fd_sc_hd__decap_8
XFILLER_30_117 VGND VGND VPWR VPWR sky130_fd_sc_hd__fill_1
XFILLER_31_629 VPWR VGND VPWR VGND sky130_ef_sc_hd__decap_12
XFILLER_30_139 VGND VGND VPWR VPWR sky130_fd_sc_hd__fill_1
XFILLER_7_27 VPWR VGND VPWR VGND sky130_ef_sc_hd__decap_12
XTAP_TAPCELL_ROW_96_1409 VGND VPWR sky130_fd_sc_hd__tapvpwrvgnd_1
XFILLER_3_541 VPWR VGND VPWR VGND sky130_ef_sc_hd__decap_12
XFILLER_87_40 VGND VGND VPWR VPWR sky130_fd_sc_hd__fill_1
XFILLER_78_320 VGND VGND VPWR VPWR sky130_fd_sc_hd__fill_1
XFILLER_3_585 VPWR VGND VPWR VGND sky130_ef_sc_hd__decap_12
XFILLER_66_537 VGND VGND VPWR VPWR sky130_fd_sc_hd__fill_1
XFILLER_38_228 VGND VGND VPWR VPWR sky130_fd_sc_hd__decap_4
XFILLER_93_334 VGND VGND VPWR VPWR sky130_fd_sc_hd__fill_2
XTAP_TAPCELL_ROW_105_1516 VGND VPWR sky130_fd_sc_hd__tapvpwrvgnd_1
XFILLER_19_486 VGND VGND VPWR VPWR sky130_fd_sc_hd__decap_3
XFILLER_34_412 VGND VGND VPWR VPWR sky130_fd_sc_hd__decap_8
XFILLER_34_467 VGND VGND VPWR VPWR sky130_fd_sc_hd__decap_8
XFILLER_99_3 VPWR VGND VPWR VGND sky130_ef_sc_hd__decap_12
XFILLER_61_275 VGND VGND VPWR VPWR sky130_fd_sc_hd__decap_4
X_5770_ _1596_ _1595_ VGND VGND VPWR VPWR _1597_ sky130_fd_sc_hd__nand2b_1
X_4721_ net458 net334 net327 net475 VGND VGND VPWR VPWR _0482_ sky130_fd_sc_hd__a22o_1
XTAP_TAPCELL_ROW_60_966 VGND VPWR sky130_fd_sc_hd__tapvpwrvgnd_1
XFILLER_14_180 VGND VGND VPWR VPWR sky130_fd_sc_hd__decap_3
XTAP_TAPCELL_ROW_32_635 VGND VPWR sky130_fd_sc_hd__tapvpwrvgnd_1
X_4652_ _0413_ VGND VGND VPWR VPWR _0414_ sky130_fd_sc_hd__inv_2
XTAP_TAPCELL_ROW_60_977 VGND VPWR sky130_fd_sc_hd__tapvpwrvgnd_1
X_3603_ net239 net416 VGND VGND VPWR VPWR _2807_ sky130_fd_sc_hd__or2_1
Xinput30 a[7] VGND VGND VPWR VPWR net30 sky130_fd_sc_hd__clkbuf_1
Xinput63 b[8] VGND VGND VPWR VPWR net63 sky130_fd_sc_hd__clkbuf_1
X_4583_ _0344_ _0345_ VGND VGND VPWR VPWR _0346_ sky130_fd_sc_hd__and2b_1
XTAP_TAPCELL_ROW_12_392 VGND VPWR sky130_fd_sc_hd__tapvpwrvgnd_1
Xinput52 b[27] VGND VGND VPWR VPWR net52 sky130_fd_sc_hd__clkbuf_2
Xinput41 b[17] VGND VGND VPWR VPWR net41 sky130_fd_sc_hd__clkbuf_1
XTAP_TAPCELL_ROW_116_1656 VGND VPWR sky130_fd_sc_hd__tapvpwrvgnd_1
XTAP_TAPCELL_ROW_116_1645 VGND VPWR sky130_fd_sc_hd__tapvpwrvgnd_1
XFILLER_115_211 VGND VGND VPWR VPWR sky130_fd_sc_hd__fill_1
Xinput74 reset VGND VGND VPWR VPWR net74 sky130_fd_sc_hd__clkbuf_1
X_6322_ net359 net430 net296 net292 VGND VGND VPWR VPWR _2199_ sky130_fd_sc_hd__and4_1
X_3534_ net346 net21 VGND VGND VPWR VPWR _2172_ sky130_fd_sc_hd__nand2_2
XFILLER_107_39 VPWR VGND VPWR VGND sky130_ef_sc_hd__decap_12
XFILLER_89_629 VPWR VGND VPWR VGND sky130_ef_sc_hd__decap_12
X_6253_ _1956_ _1958_ _2123_ VGND VGND VPWR VPWR _2124_ sky130_fd_sc_hd__a21o_1
X_3465_ net165 net439 _1408_ VGND VGND VPWR VPWR _1419_ sky130_fd_sc_hd__a21bo_1
XFILLER_103_417 VPWR VGND VPWR VGND sky130_ef_sc_hd__decap_12
X_5204_ _0979_ VGND VGND VPWR VPWR _0980_ sky130_fd_sc_hd__inv_2
XTAP_TAPCELL_ROW_4_305 VGND VPWR sky130_fd_sc_hd__tapvpwrvgnd_1
X_6184_ _2047_ VGND VGND VPWR VPWR _2048_ sky130_fd_sc_hd__inv_2
XFILLER_97_673 VPWR VGND VPWR VGND sky130_ef_sc_hd__decap_12
XFILLER_96_150 VGND VGND VPWR VPWR sky130_fd_sc_hd__decap_3
X_5135_ _0890_ _0902_ VGND VGND VPWR VPWR _0904_ sky130_fd_sc_hd__xnor2_1
XFILLER_96_183 VPWR VGND VPWR VGND sky130_ef_sc_hd__decap_12
X_5066_ _0827_ _0828_ VGND VGND VPWR VPWR _0829_ sky130_fd_sc_hd__and2_1
X_4017_ _3162_ _3164_ _3185_ _3201_ _3203_ VGND VGND VPWR VPWR _3204_ sky130_fd_sc_hd__a311o_1
XFILLER_65_570 VGND VGND VPWR VPWR sky130_fd_sc_hd__fill_1
XFILLER_25_401 VGND VGND VPWR VPWR sky130_fd_sc_hd__decap_3
XFILLER_37_261 VPWR VGND VPWR VGND sky130_ef_sc_hd__decap_12
XFILLER_52_253 VPWR VGND VPWR VGND sky130_ef_sc_hd__decap_12
XFILLER_13_629 VPWR VGND VPWR VGND sky130_ef_sc_hd__decap_12
XFILLER_40_404 VPWR VGND VPWR VGND sky130_ef_sc_hd__decap_12
XFILLER_40_426 VPWR VGND VPWR VGND sky130_ef_sc_hd__decap_12
X_5968_ _1811_ _1813_ VGND VGND VPWR VPWR _1814_ sky130_fd_sc_hd__nor2_1
X_4919_ _0660_ _0676_ _0677_ VGND VGND VPWR VPWR _0678_ sky130_fd_sc_hd__and3_1
XFILLER_12_139 VGND VGND VPWR VPWR sky130_fd_sc_hd__fill_1
X_5899_ _1736_ _1737_ VGND VGND VPWR VPWR _1738_ sky130_fd_sc_hd__and2b_1
XFILLER_21_673 VPWR VGND VPWR VGND sky130_ef_sc_hd__decap_12
XFILLER_4_349 VGND VGND VPWR VPWR sky130_fd_sc_hd__decap_8
XFILLER_106_244 VGND VGND VPWR VPWR sky130_fd_sc_hd__decap_8
XFILLER_106_277 VPWR VGND VPWR VGND sky130_ef_sc_hd__decap_12
XTAP_TAPCELL_ROW_91_1339 VGND VPWR sky130_fd_sc_hd__tapvpwrvgnd_1
XFILLER_0_533 VPWR VGND VPWR VGND sky130_ef_sc_hd__decap_12
XFILLER_87_161 VGND VGND VPWR VPWR sky130_fd_sc_hd__decap_6
XFILLER_57_76 VGND VGND VPWR VPWR sky130_fd_sc_hd__fill_1
XFILLER_28_250 VGND VGND VPWR VPWR sky130_fd_sc_hd__fill_2
XFILLER_56_570 VGND VGND VPWR VPWR sky130_fd_sc_hd__fill_1
XFILLER_113_93 VPWR VGND VPWR VGND sky130_ef_sc_hd__decap_12
XFILLER_16_434 VGND VGND VPWR VPWR sky130_fd_sc_hd__fill_1
XFILLER_73_86 VGND VGND VPWR VPWR sky130_fd_sc_hd__decap_8
XFILLER_31_415 VGND VGND VPWR VPWR sky130_fd_sc_hd__decap_8
XFILLER_43_253 VGND VGND VPWR VPWR sky130_fd_sc_hd__decap_3
XFILLER_31_437 VGND VGND VPWR VPWR sky130_fd_sc_hd__decap_8
XTAP_TAPCELL_ROW_100_1457 VGND VPWR sky130_fd_sc_hd__tapvpwrvgnd_1
XTAP_TAPCELL_ROW_100_1446 VGND VPWR sky130_fd_sc_hd__tapvpwrvgnd_1
XFILLER_7_132 VGND VGND VPWR VPWR sky130_fd_sc_hd__decap_8
XFILLER_112_225 VPWR VGND VPWR VGND sky130_ef_sc_hd__decap_12
XFILLER_98_83 VGND VGND VPWR VPWR sky130_fd_sc_hd__fill_1
XFILLER_112_269 VPWR VGND VPWR VGND sky130_ef_sc_hd__decap_12
XTAP_TAPCELL_ROW_111_1586 VGND VPWR sky130_fd_sc_hd__tapvpwrvgnd_1
XFILLER_79_673 VPWR VGND VPWR VGND sky130_ef_sc_hd__decap_12
XFILLER_66_301 VGND VGND VPWR VPWR sky130_fd_sc_hd__decap_6
XFILLER_94_643 VGND VGND VPWR VPWR sky130_fd_sc_hd__fill_1
XFILLER_14_3 VPWR VGND VPWR VGND sky130_ef_sc_hd__decap_12
XFILLER_39_537 VGND VGND VPWR VPWR sky130_fd_sc_hd__decap_8
XFILLER_39_559 VGND VGND VPWR VPWR sky130_fd_sc_hd__fill_1
XFILLER_81_337 VGND VGND VPWR VPWR sky130_fd_sc_hd__decap_3
XFILLER_66_389 VPWR VGND VPWR VGND sky130_ef_sc_hd__decap_12
XTAP_TAPCELL_ROW_66_1043 VGND VPWR sky130_fd_sc_hd__tapvpwrvgnd_1
X_6871_ _0000_ VGND VGND VPWR VPWR _0001_ sky130_fd_sc_hd__inv_2
XFILLER_34_220 VGND VGND VPWR VPWR sky130_fd_sc_hd__decap_4
XTAP_TAPCELL_ROW_17_451 VGND VPWR sky130_fd_sc_hd__tapvpwrvgnd_1
X_5822_ _1652_ _1653_ _1613_ VGND VGND VPWR VPWR _1654_ sky130_fd_sc_hd__a21o_1
XFILLER_34_253 VPWR VGND VPWR VGND sky130_ef_sc_hd__decap_12
X_5753_ _1576_ _1577_ _1349_ _1351_ VGND VGND VPWR VPWR _1579_ sky130_fd_sc_hd__o211a_1
XTAP_TAPCELL_ROW_45_793 VGND VPWR sky130_fd_sc_hd__tapvpwrvgnd_1
X_4704_ _0463_ _0465_ _0366_ _0369_ VGND VGND VPWR VPWR _0466_ sky130_fd_sc_hd__o211ai_2
X_5684_ net368 net315 net307 net375 VGND VGND VPWR VPWR _1503_ sky130_fd_sc_hd__a22o_1
XFILLER_30_492 VGND VGND VPWR VPWR sky130_fd_sc_hd__decap_3
X_4635_ _0329_ _0332_ _0395_ _0396_ VGND VGND VPWR VPWR _0398_ sky130_fd_sc_hd__a211oi_1
X_4566_ _0327_ _0328_ _0271_ VGND VGND VPWR VPWR _0330_ sky130_fd_sc_hd__o21ai_1
X_3517_ net125 _1909_ _1920_ net133 VGND VGND VPWR VPWR _1986_ sky130_fd_sc_hd__a31o_1
XTAP_TAPCELL_ROW_77_1172 VGND VPWR sky130_fd_sc_hd__tapvpwrvgnd_1
X_6305_ _2178_ _2179_ VGND VGND VPWR VPWR _2180_ sky130_fd_sc_hd__nor2_1
XFILLER_116_586 VGND VGND VPWR VPWR sky130_fd_sc_hd__fill_2
X_4497_ _0254_ _0259_ VGND VGND VPWR VPWR _0262_ sky130_fd_sc_hd__xor2_2
XFILLER_103_225 VPWR VGND VPWR VGND sky130_ef_sc_hd__decap_12
X_3448_ _1092_ net144 _1179_ _1222_ _1081_ VGND VGND VPWR VPWR _1233_ sky130_fd_sc_hd__a221o_1
X_6236_ _1934_ _1936_ _2103_ _2104_ VGND VGND VPWR VPWR _2105_ sky130_fd_sc_hd__a211oi_4
X_6167_ _2026_ _2027_ VGND VGND VPWR VPWR _2030_ sky130_fd_sc_hd__xnor2_1
X_5118_ _0884_ _0886_ VGND VGND VPWR VPWR _0887_ sky130_fd_sc_hd__and2b_1
XFILLER_84_120 VGND VGND VPWR VPWR sky130_fd_sc_hd__decap_8
XFILLER_57_345 VGND VGND VPWR VPWR sky130_fd_sc_hd__fill_2
XFILLER_85_665 VGND VGND VPWR VPWR sky130_fd_sc_hd__decap_6
XFILLER_84_153 VPWR VGND VPWR VGND sky130_ef_sc_hd__decap_12
X_6098_ net247 net441 _1803_ _1802_ VGND VGND VPWR VPWR _1955_ sky130_fd_sc_hd__a31o_1
XFILLER_84_197 VPWR VGND VPWR VGND sky130_ef_sc_hd__decap_12
X_5049_ net457 net425 net316 net308 VGND VGND VPWR VPWR _0811_ sky130_fd_sc_hd__and4_1
XFILLER_57_389 VGND VGND VPWR VPWR sky130_fd_sc_hd__decap_3
XFILLER_27_57 VPWR VGND VPWR VGND sky130_ef_sc_hd__decap_12
XFILLER_38_581 VGND VGND VPWR VPWR sky130_fd_sc_hd__fill_2
XFILLER_53_551 VGND VGND VPWR VPWR sky130_fd_sc_hd__fill_1
XFILLER_25_220 VGND VGND VPWR VPWR sky130_fd_sc_hd__decap_4
XFILLER_25_253 VGND VGND VPWR VPWR sky130_fd_sc_hd__decap_3
XFILLER_53_595 VGND VGND VPWR VPWR sky130_fd_sc_hd__fill_1
XFILLER_107_597 VPWR VGND VPWR VGND sky130_ef_sc_hd__decap_12
XFILLER_108_82 VGND VGND VPWR VPWR sky130_fd_sc_hd__fill_2
XFILLER_0_363 VGND VGND VPWR VPWR sky130_fd_sc_hd__fill_1
XFILLER_76_643 VGND VGND VPWR VPWR sky130_fd_sc_hd__fill_1
XFILLER_91_613 VGND VGND VPWR VPWR sky130_fd_sc_hd__decap_3
XFILLER_84_41 VGND VGND VPWR VPWR sky130_fd_sc_hd__decap_4
XFILLER_63_337 VPWR VGND VPWR VGND sky130_ef_sc_hd__decap_12
XFILLER_84_96 VPWR VGND VPWR VGND sky130_ef_sc_hd__decap_12
XFILLER_84_85 VGND VGND VPWR VPWR sky130_fd_sc_hd__decap_3
XTAP_TAPCELL_ROW_14_421 VGND VPWR sky130_fd_sc_hd__tapvpwrvgnd_1
XFILLER_31_245 VGND VGND VPWR VPWR sky130_fd_sc_hd__fill_1
XTAP_TAPCELL_ROW_42_752 VGND VPWR sky130_fd_sc_hd__tapvpwrvgnd_1
XFILLER_31_278 VGND VGND VPWR VPWR sky130_fd_sc_hd__fill_2
X_4420_ _alu_i0.Datapath_i.reg_0.reg_out1\[7\] _0186_ net148 VGND VGND VPWR VPWR net106
+ sky130_fd_sc_hd__mux2_1
XTAP_TAPCELL_ROW_113_1604 VGND VPWR sky130_fd_sc_hd__tapvpwrvgnd_1
X_4351_ net454 net214 net208 net471 VGND VGND VPWR VPWR _0119_ sky130_fd_sc_hd__a22oi_1
X_4282_ _0047_ _0053_ VGND VGND VPWR VPWR _0054_ sky130_fd_sc_hd__nand2_1
Xfanout409 net410 VGND VGND VPWR VPWR net409 sky130_fd_sc_hd__clkbuf_4
XFILLER_86_418 VGND VGND VPWR VPWR sky130_fd_sc_hd__fill_2
X_6021_ _1727_ _1729_ VGND VGND VPWR VPWR _1870_ sky130_fd_sc_hd__nor2_1
XFILLER_104_29 VPWR VGND VPWR VGND sky130_ef_sc_hd__decap_12
XFILLER_66_153 VPWR VGND VPWR VGND sky130_ef_sc_hd__decap_12
XFILLER_82_613 VPWR VGND VPWR VGND sky130_ef_sc_hd__decap_12
XFILLER_54_337 VPWR VGND VPWR VGND sky130_ef_sc_hd__decap_12
XFILLER_39_389 VGND VGND VPWR VPWR sky130_fd_sc_hd__decap_3
XFILLER_82_657 VPWR VGND VPWR VGND sky130_ef_sc_hd__decap_12
XFILLER_22_201 VGND VGND VPWR VPWR sky130_fd_sc_hd__fill_1
X_6854_ _2777_ _2779_ VGND VGND VPWR VPWR _2780_ sky130_fd_sc_hd__xnor2_1
XFILLER_22_223 VGND VGND VPWR VPWR sky130_fd_sc_hd__decap_8
XFILLER_13_15 VPWR VGND VPWR VGND sky130_ef_sc_hd__decap_12
X_5805_ _1634_ _1633_ _1632_ VGND VGND VPWR VPWR _1635_ sky130_fd_sc_hd__nand3b_1
X_6785_ net405 net52 VGND VGND VPWR VPWR _2704_ sky130_fd_sc_hd__nand2_1
X_3997_ _3182_ _3184_ VGND VGND VPWR VPWR _3185_ sky130_fd_sc_hd__nor2_2
X_5736_ _1557_ _1558_ _1367_ _1369_ VGND VGND VPWR VPWR _1560_ sky130_fd_sc_hd__o211ai_2
XFILLER_50_587 VGND VGND VPWR VPWR sky130_fd_sc_hd__fill_1
XTAP_TAPCELL_ROW_79_1201 VGND VPWR sky130_fd_sc_hd__tapvpwrvgnd_1
X_5667_ net219 net186 net341 net259 VGND VGND VPWR VPWR _1485_ sky130_fd_sc_hd__a22o_1
X_4618_ _0370_ _0379_ _0380_ VGND VGND VPWR VPWR _0381_ sky130_fd_sc_hd__nand3_1
X_5598_ _1406_ _1407_ _1281_ _1285_ VGND VGND VPWR VPWR _1410_ sky130_fd_sc_hd__a211o_1
X_4549_ net415 net407 net208 net201 VGND VGND VPWR VPWR _0313_ sky130_fd_sc_hd__nand4_1
XFILLER_1_105 VGND VGND VPWR VPWR sky130_fd_sc_hd__fill_1
XFILLER_104_545 VPWR VGND VPWR VGND sky130_ef_sc_hd__decap_12
XFILLER_104_589 VPWR VGND VPWR VGND sky130_ef_sc_hd__decap_12
XFILLER_77_407 VPWR VGND VPWR VGND sky130_ef_sc_hd__decap_12
X_6219_ net359 net301 _1879_ _1878_ VGND VGND VPWR VPWR _2087_ sky130_fd_sc_hd__a31o_1
XFILLER_58_621 VPWR VGND VPWR VGND sky130_ef_sc_hd__decap_12
XFILLER_57_142 VGND VGND VPWR VPWR sky130_fd_sc_hd__decap_8
XFILLER_57_131 VGND VGND VPWR VPWR sky130_fd_sc_hd__fill_2
XFILLER_73_624 VPWR VGND VPWR VGND sky130_ef_sc_hd__decap_12
XFILLER_73_613 VGND VGND VPWR VPWR sky130_fd_sc_hd__decap_3
XFILLER_18_518 VPWR VGND VPWR VGND sky130_ef_sc_hd__decap_12
XFILLER_72_123 VPWR VGND VPWR VGND sky130_ef_sc_hd__decap_12
XFILLER_26_573 VGND VGND VPWR VPWR sky130_fd_sc_hd__fill_1
XFILLER_41_554 VGND VGND VPWR VPWR sky130_fd_sc_hd__fill_1
XFILLER_41_565 VGND VGND VPWR VPWR sky130_fd_sc_hd__fill_1
XFILLER_110_83 VGND VGND VPWR VPWR sky130_fd_sc_hd__fill_1
XFILLER_9_238 VPWR VGND VPWR VGND sky130_ef_sc_hd__decap_12
XFILLER_70_65 VGND VGND VPWR VPWR sky130_fd_sc_hd__decap_8
XFILLER_114_309 VGND VGND VPWR VPWR sky130_fd_sc_hd__fill_1
XFILLER_107_361 VPWR VGND VPWR VGND sky130_ef_sc_hd__decap_12
XFILLER_79_96 VGND VGND VPWR VPWR sky130_fd_sc_hd__decap_8
XFILLER_68_429 VGND VGND VPWR VPWR sky130_fd_sc_hd__decap_3
XFILLER_95_237 VPWR VGND VPWR VGND sky130_ef_sc_hd__decap_12
XFILLER_49_610 VGND VGND VPWR VPWR sky130_fd_sc_hd__decap_6
XFILLER_76_451 VGND VGND VPWR VPWR sky130_fd_sc_hd__fill_1
XFILLER_48_131 VGND VGND VPWR VPWR sky130_fd_sc_hd__decap_4
XFILLER_49_665 VGND VGND VPWR VPWR sky130_fd_sc_hd__decap_6
XFILLER_36_315 VGND VGND VPWR VPWR sky130_fd_sc_hd__decap_8
XTAP_TAPCELL_ROW_47_811 VGND VPWR sky130_fd_sc_hd__tapvpwrvgnd_1
XFILLER_91_443 VGND VGND VPWR VPWR sky130_fd_sc_hd__decap_4
XFILLER_64_657 VPWR VGND VPWR VGND sky130_ef_sc_hd__decap_12
XFILLER_48_197 VGND VGND VPWR VPWR sky130_fd_sc_hd__decap_3
XFILLER_63_167 VGND VGND VPWR VPWR sky130_fd_sc_hd__fill_1
X_3920_ net170 net306 VGND VGND VPWR VPWR _3111_ sky130_fd_sc_hd__nand2_2
XTAP_TAPCELL_ROW_63_1013 VGND VPWR sky130_fd_sc_hd__tapvpwrvgnd_1
XTAP_TAPCELL_ROW_63_1002 VGND VPWR sky130_fd_sc_hd__tapvpwrvgnd_1
X_3851_ _2859_ _2864_ net154 VGND VGND VPWR VPWR _3046_ sky130_fd_sc_hd__mux2_1
XFILLER_32_554 VPWR VGND VPWR VGND sky130_ef_sc_hd__decap_12
XFILLER_81_3 VPWR VGND VPWR VGND sky130_ef_sc_hd__decap_12
X_3782_ net117 _2972_ _2979_ VGND VGND VPWR VPWR _2980_ sky130_fd_sc_hd__a21o_1
X_6570_ _2449_ _2468_ _2470_ VGND VGND VPWR VPWR _2471_ sky130_fd_sc_hd__and3_1
X_5521_ _1197_ _1199_ _1324_ _1325_ VGND VGND VPWR VPWR _1326_ sky130_fd_sc_hd__a211o_1
X_5452_ _1249_ VGND VGND VPWR VPWR _1250_ sky130_fd_sc_hd__inv_2
X_4403_ _0161_ _0169_ VGND VGND VPWR VPWR _0170_ sky130_fd_sc_hd__xnor2_1
X_5383_ net315 _1174_ VGND VGND VPWR VPWR _1175_ sky130_fd_sc_hd__and2_1
X_4334_ _0100_ _0101_ _0093_ VGND VGND VPWR VPWR _0103_ sky130_fd_sc_hd__o21ai_1
XTAP_TAPCELL_ROW_74_1142 VGND VPWR sky130_fd_sc_hd__tapvpwrvgnd_1
Xfanout217 net60 VGND VGND VPWR VPWR net217 sky130_fd_sc_hd__buf_2
XFILLER_86_204 VGND VGND VPWR VPWR sky130_fd_sc_hd__fill_1
Xfanout228 net229 VGND VGND VPWR VPWR net228 sky130_fd_sc_hd__dlymetal6s2s_1
XFILLER_59_429 VPWR VGND VPWR VGND sky130_ef_sc_hd__decap_12
Xfanout206 net207 VGND VGND VPWR VPWR net206 sky130_fd_sc_hd__clkbuf_4
XFILLER_115_39 VPWR VGND VPWR VGND sky130_ef_sc_hd__decap_12
XFILLER_113_386 VGND VGND VPWR VPWR sky130_fd_sc_hd__decap_6
Xfanout239 net243 VGND VGND VPWR VPWR net239 sky130_fd_sc_hd__clkbuf_4
X_4265_ net278 net161 _3403_ _0039_ VGND VGND VPWR VPWR _0040_ sky130_fd_sc_hd__a31o_1
X_6004_ _1849_ _1850_ _1699_ _1701_ VGND VGND VPWR VPWR _1852_ sky130_fd_sc_hd__a211oi_1
X_4196_ _3334_ _3335_ _3357_ VGND VGND VPWR VPWR _3375_ sky130_fd_sc_hd__a21o_1
XFILLER_39_164 VGND VGND VPWR VPWR sky130_fd_sc_hd__decap_4
XFILLER_94_292 VGND VGND VPWR VPWR sky130_fd_sc_hd__decap_8
XFILLER_94_281 VGND VGND VPWR VPWR sky130_fd_sc_hd__fill_1
XFILLER_82_421 VGND VGND VPWR VPWR sky130_fd_sc_hd__decap_4
XFILLER_27_337 VGND VGND VPWR VPWR sky130_fd_sc_hd__decap_3
XTAP_TAPCELL_ROW_85_1271 VGND VPWR sky130_fd_sc_hd__tapvpwrvgnd_1
X_6906_ net180 _0000_ VGND VGND VPWR VPWR net76 sky130_fd_sc_hd__dfxtp_1
XTAP_TAPCELL_ROW_25_549 VGND VPWR sky130_fd_sc_hd__tapvpwrvgnd_1
XFILLER_35_370 VGND VGND VPWR VPWR sky130_fd_sc_hd__fill_2
X_6837_ _2757_ _2760_ VGND VGND VPWR VPWR _2762_ sky130_fd_sc_hd__xnor2_1
XFILLER_23_587 VPWR VGND VPWR VGND sky130_ef_sc_hd__decap_12
XFILLER_50_373 VPWR VGND VPWR VGND sky130_ef_sc_hd__decap_12
XFILLER_109_615 VGND VGND VPWR VPWR sky130_fd_sc_hd__fill_1
XFILLER_10_226 VPWR VGND VPWR VGND sky130_ef_sc_hd__decap_12
X_6768_ net442 net193 _2557_ _2558_ net185 VGND VGND VPWR VPWR _2686_ sky130_fd_sc_hd__a32o_1
X_6699_ _2609_ _2610_ VGND VGND VPWR VPWR _2611_ sky130_fd_sc_hd__nor2_1
X_5719_ _1364_ _1540_ VGND VGND VPWR VPWR _1542_ sky130_fd_sc_hd__xnor2_2
XFILLER_108_158 VGND VGND VPWR VPWR sky130_fd_sc_hd__decap_4
XFILLER_2_403 VGND VGND VPWR VPWR sky130_fd_sc_hd__decap_8
XFILLER_2_458 VPWR VGND VPWR VGND sky130_ef_sc_hd__decap_12
XFILLER_49_33 VPWR VGND VPWR VGND sky130_ef_sc_hd__decap_12
XFILLER_77_237 VGND VGND VPWR VPWR sky130_fd_sc_hd__fill_2
XFILLER_49_66 VPWR VGND VPWR VGND sky130_ef_sc_hd__decap_12
XFILLER_77_248 VGND VGND VPWR VPWR sky130_fd_sc_hd__decap_8
XFILLER_105_83 VGND VGND VPWR VPWR sky130_fd_sc_hd__decap_4
XFILLER_100_581 VGND VGND VPWR VPWR sky130_fd_sc_hd__decap_6
XFILLER_65_32 VPWR VGND VPWR VGND sky130_ef_sc_hd__decap_12
XFILLER_46_624 VPWR VGND VPWR VGND sky130_ef_sc_hd__decap_12
XFILLER_85_281 VGND VGND VPWR VPWR sky130_fd_sc_hd__decap_4
XFILLER_65_54 VGND VGND VPWR VPWR sky130_fd_sc_hd__fill_2
XFILLER_46_657 VPWR VGND VPWR VGND sky130_ef_sc_hd__decap_12
XFILLER_45_167 VGND VGND VPWR VPWR sky130_fd_sc_hd__fill_1
XFILLER_41_340 VPWR VGND VPWR VGND sky130_ef_sc_hd__decap_12
XFILLER_81_75 VGND VGND VPWR VPWR sky130_fd_sc_hd__decap_6
XTAP_TAPCELL_ROW_52_880 VGND VPWR sky130_fd_sc_hd__tapvpwrvgnd_1
XFILLER_14_587 VGND VGND VPWR VPWR sky130_fd_sc_hd__fill_1
XFILLER_60_8 VGND VGND VPWR VPWR sky130_fd_sc_hd__fill_1
XFILLER_115_629 VPWR VGND VPWR VGND sky130_ef_sc_hd__decap_12
XFILLER_108_681 VGND VGND VPWR VPWR sky130_fd_sc_hd__decap_8
XFILLER_1_480 VPWR VGND VPWR VGND sky130_ef_sc_hd__decap_12
XFILLER_110_345 VGND VGND VPWR VPWR sky130_fd_sc_hd__fill_2
X_4050_ _3235_ net123 _3234_ VGND VGND VPWR VPWR _3236_ sky130_fd_sc_hd__and3b_1
Xinput6 a[14] VGND VGND VPWR VPWR net6 sky130_fd_sc_hd__clkbuf_4
XFILLER_49_484 VGND VGND VPWR VPWR sky130_fd_sc_hd__decap_8
XTAP_TAPCELL_ROW_108_1547 VGND VPWR sky130_fd_sc_hd__tapvpwrvgnd_1
XFILLER_64_421 VGND VGND VPWR VPWR sky130_fd_sc_hd__decap_4
XFILLER_36_134 VGND VGND VPWR VPWR sky130_fd_sc_hd__decap_6
XFILLER_64_465 VGND VGND VPWR VPWR sky130_fd_sc_hd__decap_8
X_4952_ _0624_ _0708_ VGND VGND VPWR VPWR _0710_ sky130_fd_sc_hd__nor2_1
XFILLER_17_370 VPWR VGND VPWR VGND sky130_ef_sc_hd__decap_12
XFILLER_36_189 VGND VGND VPWR VPWR sky130_fd_sc_hd__decap_6
XFILLER_51_104 VGND VGND VPWR VPWR sky130_fd_sc_hd__decap_4
X_4883_ _0640_ _0641_ VGND VGND VPWR VPWR _0642_ sky130_fd_sc_hd__nand2_1
X_3903_ net174 net318 VGND VGND VPWR VPWR _3095_ sky130_fd_sc_hd__and2_1
X_3834_ _2986_ _3005_ _3028_ VGND VGND VPWR VPWR _3029_ sky130_fd_sc_hd__a21oi_2
X_6622_ _2363_ _2372_ _2371_ VGND VGND VPWR VPWR _2526_ sky130_fd_sc_hd__a21oi_1
XFILLER_20_502 VGND VGND VPWR VPWR sky130_fd_sc_hd__fill_2
XTAP_TAPCELL_ROW_22_519 VGND VPWR sky130_fd_sc_hd__tapvpwrvgnd_1
X_3765_ net365 net189 VGND VGND VPWR VPWR _2963_ sky130_fd_sc_hd__and2_2
X_6553_ net440 net205 net198 net442 VGND VGND VPWR VPWR _2452_ sky130_fd_sc_hd__a22oi_1
X_3696_ _2844_ _2850_ _2869_ _2842_ VGND VGND VPWR VPWR _2897_ sky130_fd_sc_hd__a211o_1
X_6484_ _2210_ _2212_ _2374_ _2375_ VGND VGND VPWR VPWR _2376_ sky130_fd_sc_hd__o211a_1
X_5504_ _1292_ _1306_ VGND VGND VPWR VPWR _1307_ sky130_fd_sc_hd__or2_2
X_5435_ _1159_ _1167_ _1166_ VGND VGND VPWR VPWR _1231_ sky130_fd_sc_hd__a21o_1
XFILLER_10_27 VGND VGND VPWR VPWR sky130_fd_sc_hd__fill_1
X_5366_ _2981_ _1153_ _1155_ VGND VGND VPWR VPWR _1156_ sky130_fd_sc_hd__o21ba_1
XFILLER_99_373 VGND VGND VPWR VPWR sky130_fd_sc_hd__fill_1
X_4317_ _0084_ _0085_ VGND VGND VPWR VPWR _0087_ sky130_fd_sc_hd__xnor2_1
X_5297_ _1036_ _1038_ _1079_ _1080_ VGND VGND VPWR VPWR _1082_ sky130_fd_sc_hd__and4bb_1
X_4248_ _3344_ _0023_ net161 VGND VGND VPWR VPWR _0024_ sky130_fd_sc_hd__mux2_1
XTAP_TAPCELL_ROW_87_1300 VGND VPWR sky130_fd_sc_hd__tapvpwrvgnd_1
XFILLER_28_613 VPWR VGND VPWR VGND sky130_ef_sc_hd__decap_12
XFILLER_67_292 VGND VGND VPWR VPWR sky130_fd_sc_hd__fill_1
XFILLER_28_657 VPWR VGND VPWR VGND sky130_ef_sc_hd__decap_12
X_4179_ _3353_ _3358_ net124 VGND VGND VPWR VPWR _3359_ sky130_fd_sc_hd__o21ai_1
XTAP_TAPCELL_ROW_2_277 VGND VPWR sky130_fd_sc_hd__tapvpwrvgnd_1
XFILLER_27_156 VGND VGND VPWR VPWR sky130_fd_sc_hd__decap_4
XFILLER_35_57 VPWR VGND VPWR VGND sky130_ef_sc_hd__decap_12
XFILLER_11_502 VGND VGND VPWR VPWR sky130_fd_sc_hd__fill_2
XFILLER_51_671 VGND VGND VPWR VPWR sky130_fd_sc_hd__fill_1
XPHY_EDGE_ROW_14_Right_14 VGND VGND VPWR VPWR sky130_fd_sc_hd__decap_3
XFILLER_51_45 VGND VGND VPWR VPWR sky130_fd_sc_hd__decap_4
XFILLER_7_517 VPWR VGND VPWR VGND sky130_ef_sc_hd__decap_12
XFILLER_109_445 VGND VGND VPWR VPWR sky130_fd_sc_hd__decap_3
XFILLER_105_673 VPWR VGND VPWR VGND sky130_ef_sc_hd__decap_12
XFILLER_104_183 VPWR VGND VPWR VGND sky130_ef_sc_hd__decap_12
XFILLER_78_513 VPWR VGND VPWR VGND sky130_ef_sc_hd__decap_12
XPHY_EDGE_ROW_23_Right_23 VGND VGND VPWR VPWR sky130_fd_sc_hd__decap_3
XFILLER_93_505 VPWR VGND VPWR VGND sky130_ef_sc_hd__decap_12
XFILLER_78_579 VGND VGND VPWR VPWR sky130_fd_sc_hd__decap_8
XFILLER_58_281 VGND VGND VPWR VPWR sky130_fd_sc_hd__decap_6
XFILLER_18_112 VPWR VGND VPWR VGND sky130_ef_sc_hd__decap_12
XFILLER_46_421 VPWR VGND VPWR VGND sky130_ef_sc_hd__decap_12
XFILLER_46_443 VGND VGND VPWR VPWR sky130_fd_sc_hd__decap_8
XFILLER_18_145 VGND VGND VPWR VPWR sky130_fd_sc_hd__fill_1
XFILLER_92_41 VGND VGND VPWR VPWR sky130_fd_sc_hd__decap_4
XFILLER_18_189 VGND VGND VPWR VPWR sky130_fd_sc_hd__fill_1
XFILLER_92_85 VGND VGND VPWR VPWR sky130_fd_sc_hd__fill_1
XFILLER_14_340 VPWR VGND VPWR VGND sky130_ef_sc_hd__decap_12
XPHY_EDGE_ROW_32_Right_32 VGND VGND VPWR VPWR sky130_fd_sc_hd__decap_3
XTAP_TAPCELL_ROW_103_1488 VGND VPWR sky130_fd_sc_hd__tapvpwrvgnd_1
X_3550_ net163 net176 _2335_ VGND VGND VPWR VPWR _2346_ sky130_fd_sc_hd__a21bo_1
X_5220_ _alu_i0.Datapath_i.reg_0.reg_out1\[18\] _0997_ net146 VGND VGND VPWR VPWR
+ net86 sky130_fd_sc_hd__mux2_1
X_3481_ net350 net282 net473 VGND VGND VPWR VPWR _1593_ sky130_fd_sc_hd__or3b_1
XTAP_TAPCELL_ROW_71_1101 VGND VPWR sky130_fd_sc_hd__tapvpwrvgnd_1
XPHY_EDGE_ROW_41_Right_41 VGND VGND VPWR VPWR sky130_fd_sc_hd__decap_3
XFILLER_44_3 VPWR VGND VPWR VGND sky130_ef_sc_hd__decap_12
X_5151_ _0918_ _0919_ _0908_ VGND VGND VPWR VPWR _0922_ sky130_fd_sc_hd__a21oi_1
XFILLER_69_513 VPWR VGND VPWR VGND sky130_ef_sc_hd__decap_12
XFILLER_111_665 VGND VGND VPWR VPWR sky130_fd_sc_hd__decap_6
XFILLER_110_131 VGND VGND VPWR VPWR sky130_fd_sc_hd__decap_8
XFILLER_96_343 VPWR VGND VPWR VGND sky130_ef_sc_hd__decap_12
X_5082_ _1288_ _0845_ VGND VGND VPWR VPWR _0847_ sky130_fd_sc_hd__xnor2_1
X_4102_ _3283_ _3284_ VGND VGND VPWR VPWR _3285_ sky130_fd_sc_hd__and2_1
XFILLER_96_365 VGND VGND VPWR VPWR sky130_fd_sc_hd__decap_8
X_4033_ _3136_ _3219_ _0787_ VGND VGND VPWR VPWR _3220_ sky130_fd_sc_hd__mux2_1
XFILLER_110_197 VPWR VGND VPWR VGND sky130_ef_sc_hd__decap_12
XFILLER_2_83 VGND VGND VPWR VPWR sky130_fd_sc_hd__fill_1
XFILLER_49_281 VPWR VGND VPWR VGND sky130_ef_sc_hd__decap_12
XFILLER_112_29 VPWR VGND VPWR VGND sky130_ef_sc_hd__decap_12
XFILLER_64_251 VGND VGND VPWR VPWR sky130_fd_sc_hd__fill_1
XTAP_TAPCELL_ROW_55_909 VGND VPWR sky130_fd_sc_hd__tapvpwrvgnd_1
XTAP_TAPCELL_ROW_69_1085 VGND VPWR sky130_fd_sc_hd__tapvpwrvgnd_1
XTAP_TAPCELL_ROW_69_1074 VGND VPWR sky130_fd_sc_hd__tapvpwrvgnd_1
XPHY_EDGE_ROW_50_Right_50 VGND VGND VPWR VPWR sky130_fd_sc_hd__decap_3
XTAP_TAPCELL_ROW_82_1241 VGND VPWR sky130_fd_sc_hd__tapvpwrvgnd_1
XTAP_TAPCELL_ROW_82_1230 VGND VPWR sky130_fd_sc_hd__tapvpwrvgnd_1
XFILLER_24_137 VGND VGND VPWR VPWR sky130_fd_sc_hd__decap_3
XFILLER_24_148 VGND VGND VPWR VPWR sky130_fd_sc_hd__decap_6
X_5984_ _1819_ _1829_ _1830_ VGND VGND VPWR VPWR _1831_ sky130_fd_sc_hd__and3_2
X_4935_ _0609_ _0611_ _0692_ _0693_ VGND VGND VPWR VPWR _0694_ sky130_fd_sc_hd__a211oi_2
XFILLER_33_671 VGND VGND VPWR VPWR sky130_fd_sc_hd__fill_1
XTAP_TAPCELL_ROW_35_666 VGND VPWR sky130_fd_sc_hd__tapvpwrvgnd_1
XTAP_TAPCELL_ROW_35_677 VGND VPWR sky130_fd_sc_hd__tapvpwrvgnd_1
XFILLER_40_619 VPWR VGND VPWR VGND sky130_ef_sc_hd__decap_12
X_4866_ net380 net194 VGND VGND VPWR VPWR _0625_ sky130_fd_sc_hd__nand2_1
XANTENNA_11 opcode[6] VGND VGND VPWR VPWR sky130_fd_sc_hd__diode_2
XANTENNA_22 net188 VGND VGND VPWR VPWR sky130_fd_sc_hd__diode_2
X_4797_ _0555_ _0556_ VGND VGND VPWR VPWR _0557_ sky130_fd_sc_hd__and2b_1
X_3817_ _2981_ _2986_ _3005_ _3012_ VGND VGND VPWR VPWR _3013_ sky130_fd_sc_hd__o31a_1
XANTENNA_33 net384 VGND VGND VPWR VPWR sky130_fd_sc_hd__diode_2
X_6605_ _2341_ _2506_ VGND VGND VPWR VPWR _2507_ sky130_fd_sc_hd__xor2_1
X_3748_ _2945_ _2946_ VGND VGND VPWR VPWR _2947_ sky130_fd_sc_hd__nand2_1
XFILLER_21_15 VPWR VGND VPWR VGND sky130_ef_sc_hd__decap_12
X_6536_ _2432_ net428 net245 _2430_ VGND VGND VPWR VPWR _2433_ sky130_fd_sc_hd__and4b_1
X_3679_ _2128_ _2193_ net248 VGND VGND VPWR VPWR _2881_ sky130_fd_sc_hd__mux2_1
X_6467_ _2194_ _2356_ VGND VGND VPWR VPWR _2358_ sky130_fd_sc_hd__xnor2_1
XTAP_TAPCELL_ROW_93_1370 VGND VPWR sky130_fd_sc_hd__tapvpwrvgnd_1
X_5418_ _1208_ _1213_ VGND VGND VPWR VPWR _1214_ sky130_fd_sc_hd__xor2_1
X_6398_ _2133_ _2135_ VGND VGND VPWR VPWR _2283_ sky130_fd_sc_hd__nand2_1
X_5349_ _1136_ _1137_ _1117_ VGND VGND VPWR VPWR _1138_ sky130_fd_sc_hd__a21o_1
XTAP_TAPCELL_ROW_7_336 VGND VPWR sky130_fd_sc_hd__tapvpwrvgnd_1
XFILLER_102_643 VGND VGND VPWR VPWR sky130_fd_sc_hd__fill_1
XFILLER_75_505 VPWR VGND VPWR VGND sky130_ef_sc_hd__decap_12
XFILLER_28_421 VPWR VGND VPWR VGND sky130_ef_sc_hd__decap_12
XFILLER_46_56 VPWR VGND VPWR VGND sky130_ef_sc_hd__decap_12
XFILLER_55_273 VGND VGND VPWR VPWR sky130_fd_sc_hd__decap_6
XFILLER_28_498 VGND VGND VPWR VPWR sky130_fd_sc_hd__decap_4
XFILLER_43_435 VGND VGND VPWR VPWR sky130_fd_sc_hd__fill_1
XFILLER_15_148 VPWR VGND VPWR VGND sky130_ef_sc_hd__decap_12
XFILLER_31_608 VGND VGND VPWR VPWR sky130_fd_sc_hd__decap_8
XFILLER_109_220 VGND VGND VPWR VPWR sky130_fd_sc_hd__decap_4
XFILLER_7_39 VPWR VGND VPWR VGND sky130_ef_sc_hd__decap_12
XFILLER_112_407 VPWR VGND VPWR VGND sky130_ef_sc_hd__decap_12
XFILLER_3_553 VGND VGND VPWR VPWR sky130_fd_sc_hd__decap_6
XFILLER_3_597 VPWR VGND VPWR VGND sky130_ef_sc_hd__decap_12
XFILLER_78_354 VGND VGND VPWR VPWR sky130_fd_sc_hd__decap_8
XFILLER_93_302 VPWR VGND VPWR VGND sky130_ef_sc_hd__decap_12
XFILLER_19_421 VPWR VGND VPWR VGND sky130_ef_sc_hd__decap_12
XFILLER_74_560 VGND VGND VPWR VPWR sky130_fd_sc_hd__fill_2
XFILLER_46_251 VGND VGND VPWR VPWR sky130_fd_sc_hd__fill_1
XTAP_TAPCELL_ROW_105_1517 VGND VPWR sky130_fd_sc_hd__tapvpwrvgnd_1
XTAP_TAPCELL_ROW_105_1506 VGND VPWR sky130_fd_sc_hd__tapvpwrvgnd_1
XFILLER_19_498 VGND VGND VPWR VPWR sky130_fd_sc_hd__decap_6
XFILLER_46_262 VGND VGND VPWR VPWR sky130_fd_sc_hd__fill_1
XFILLER_61_232 VGND VGND VPWR VPWR sky130_fd_sc_hd__decap_8
XFILLER_61_265 VGND VGND VPWR VPWR sky130_fd_sc_hd__decap_3
XFILLER_15_671 VGND VGND VPWR VPWR sky130_fd_sc_hd__fill_1
X_4720_ net475 net458 net334 net327 VGND VGND VPWR VPWR _0481_ sky130_fd_sc_hd__nand4_1
XFILLER_30_641 VGND VGND VPWR VPWR sky130_fd_sc_hd__decap_3
XTAP_TAPCELL_ROW_32_636 VGND VPWR sky130_fd_sc_hd__tapvpwrvgnd_1
X_4651_ net458 net338 net334 net474 VGND VGND VPWR VPWR _0413_ sky130_fd_sc_hd__a22o_1
XTAP_TAPCELL_ROW_60_967 VGND VPWR sky130_fd_sc_hd__tapvpwrvgnd_1
X_3602_ net239 net416 VGND VGND VPWR VPWR _2806_ sky130_fd_sc_hd__nand2_1
Xinput31 a[8] VGND VGND VPWR VPWR net31 sky130_fd_sc_hd__clkbuf_2
Xinput20 a[27] VGND VGND VPWR VPWR net20 sky130_fd_sc_hd__dlymetal6s2s_1
Xinput64 b[9] VGND VGND VPWR VPWR net64 sky130_fd_sc_hd__dlymetal6s2s_1
X_4582_ net424 net189 net344 net457 VGND VGND VPWR VPWR _0345_ sky130_fd_sc_hd__a22o_1
XTAP_TAPCELL_ROW_12_393 VGND VPWR sky130_fd_sc_hd__tapvpwrvgnd_1
Xinput42 b[18] VGND VGND VPWR VPWR net42 sky130_fd_sc_hd__buf_2
Xinput53 b[28] VGND VGND VPWR VPWR net53 sky130_fd_sc_hd__clkbuf_4
XTAP_TAPCELL_ROW_116_1657 VGND VPWR sky130_fd_sc_hd__tapvpwrvgnd_1
XTAP_TAPCELL_ROW_116_1646 VGND VPWR sky130_fd_sc_hd__tapvpwrvgnd_1
XFILLER_115_223 VGND VGND VPWR VPWR sky130_fd_sc_hd__fill_1
XFILLER_115_201 VGND VGND VPWR VPWR sky130_fd_sc_hd__decap_3
Xinput75 start_port VGND VGND VPWR VPWR net75 sky130_fd_sc_hd__clkbuf_1
X_6321_ net430 net296 net292 net359 VGND VGND VPWR VPWR _2198_ sky130_fd_sc_hd__a22oi_1
X_3533_ net347 _0874_ _2150_ VGND VGND VPWR VPWR _2161_ sky130_fd_sc_hd__o21a_1
XFILLER_115_245 VGND VGND VPWR VPWR sky130_fd_sc_hd__fill_2
X_6252_ _2121_ _2122_ VGND VGND VPWR VPWR _2123_ sky130_fd_sc_hd__nand2_1
X_3464_ net351 net437 VGND VGND VPWR VPWR _1408_ sky130_fd_sc_hd__nand2_1
XFILLER_115_278 VGND VGND VPWR VPWR sky130_fd_sc_hd__fill_2
XFILLER_103_429 VPWR VGND VPWR VGND sky130_ef_sc_hd__decap_12
XFILLER_88_118 VGND VGND VPWR VPWR sky130_fd_sc_hd__fill_1
XFILLER_88_107 VGND VGND VPWR VPWR sky130_fd_sc_hd__decap_4
X_5203_ _0873_ _0977_ _0978_ VGND VGND VPWR VPWR _0979_ sky130_fd_sc_hd__and3_1
X_6183_ net390 net271 net268 net397 VGND VGND VPWR VPWR _2047_ sky130_fd_sc_hd__a22o_1
XFILLER_97_641 VPWR VGND VPWR VGND sky130_ef_sc_hd__decap_12
X_5134_ _0890_ _0902_ VGND VGND VPWR VPWR _0903_ sky130_fd_sc_hd__nand2b_1
XFILLER_69_343 VGND VGND VPWR VPWR sky130_fd_sc_hd__fill_1
XFILLER_97_685 VGND VGND VPWR VPWR sky130_fd_sc_hd__decap_6
XFILLER_84_302 VGND VGND VPWR VPWR sky130_fd_sc_hd__decap_6
XFILLER_57_505 VGND VGND VPWR VPWR sky130_fd_sc_hd__decap_8
XFILLER_96_195 VGND VGND VPWR VPWR sky130_fd_sc_hd__fill_1
X_5065_ _0793_ _0826_ VGND VGND VPWR VPWR _0828_ sky130_fd_sc_hd__nand2_1
XFILLER_72_508 VPWR VGND VPWR VGND sky130_ef_sc_hd__decap_12
X_4016_ _3096_ _3120_ _3144_ _3202_ _3114_ VGND VGND VPWR VPWR _3203_ sky130_fd_sc_hd__a2111oi_1
XFILLER_65_593 VPWR VGND VPWR VGND sky130_ef_sc_hd__decap_12
XFILLER_16_15 VPWR VGND VPWR VGND sky130_ef_sc_hd__decap_12
XFILLER_37_273 VGND VGND VPWR VPWR sky130_fd_sc_hd__decap_6
XFILLER_80_530 VGND VGND VPWR VPWR sky130_fd_sc_hd__fill_2
XFILLER_52_232 VGND VGND VPWR VPWR sky130_fd_sc_hd__decap_3
X_5967_ _1666_ _1667_ _1665_ VGND VGND VPWR VPWR _1813_ sky130_fd_sc_hd__a21oi_1
XFILLER_52_265 VPWR VGND VPWR VGND sky130_ef_sc_hd__decap_12
X_4918_ _0674_ _0675_ _0590_ _0593_ VGND VGND VPWR VPWR _0677_ sky130_fd_sc_hd__o211ai_1
XFILLER_80_596 VGND VGND VPWR VPWR sky130_fd_sc_hd__fill_1
XFILLER_40_438 VPWR VGND VPWR VGND sky130_ef_sc_hd__decap_12
X_5898_ net403 net272 net269 net411 VGND VGND VPWR VPWR _1737_ sky130_fd_sc_hd__a22o_1
XFILLER_21_641 VPWR VGND VPWR VGND sky130_ef_sc_hd__decap_12
X_4849_ _0529_ _0532_ _0607_ _0608_ VGND VGND VPWR VPWR _0609_ sky130_fd_sc_hd__a211o_2
XFILLER_21_685 VGND VGND VPWR VPWR sky130_fd_sc_hd__decap_4
XFILLER_20_195 VGND VGND VPWR VPWR sky130_fd_sc_hd__fill_1
XFILLER_4_317 VGND VGND VPWR VPWR sky130_fd_sc_hd__decap_8
X_6519_ _2413_ _2414_ VGND VGND VPWR VPWR _2415_ sky130_fd_sc_hd__nand2_1
XFILLER_106_289 VPWR VGND VPWR VGND sky130_ef_sc_hd__decap_12
XFILLER_0_501 VGND VGND VPWR VPWR sky130_fd_sc_hd__decap_3
XFILLER_0_545 VPWR VGND VPWR VGND sky130_ef_sc_hd__decap_12
XFILLER_102_451 VGND VGND VPWR VPWR sky130_fd_sc_hd__decap_3
XFILLER_0_589 VPWR VGND VPWR VGND sky130_ef_sc_hd__decap_12
XFILLER_57_55 VGND VGND VPWR VPWR sky130_fd_sc_hd__fill_1
XFILLER_90_305 VGND VGND VPWR VPWR sky130_fd_sc_hd__decap_3
XFILLER_75_357 VGND VGND VPWR VPWR sky130_fd_sc_hd__decap_3
XFILLER_28_284 VGND VGND VPWR VPWR sky130_fd_sc_hd__decap_6
XFILLER_73_54 VGND VGND VPWR VPWR sky130_fd_sc_hd__fill_2
XFILLER_43_232 VGND VGND VPWR VPWR sky130_fd_sc_hd__decap_8
XFILLER_16_468 VGND VGND VPWR VPWR sky130_fd_sc_hd__decap_8
XFILLER_31_449 VGND VGND VPWR VPWR sky130_fd_sc_hd__decap_6
XTAP_TAPCELL_ROW_100_1447 VGND VPWR sky130_fd_sc_hd__tapvpwrvgnd_1
XFILLER_8_601 VPWR VGND VPWR VGND sky130_ef_sc_hd__decap_12
XFILLER_11_151 VGND VGND VPWR VPWR sky130_fd_sc_hd__fill_1
XFILLER_8_645 VPWR VGND VPWR VGND sky130_ef_sc_hd__decap_12
XFILLER_8_689 VGND VGND VPWR VPWR sky130_fd_sc_hd__decap_3
XFILLER_98_405 VPWR VGND VPWR VGND sky130_ef_sc_hd__decap_12
XFILLER_98_95 VGND VGND VPWR VPWR sky130_fd_sc_hd__decap_8
XFILLER_79_641 VPWR VGND VPWR VGND sky130_ef_sc_hd__decap_12
XTAP_TAPCELL_ROW_111_1587 VGND VPWR sky130_fd_sc_hd__tapvpwrvgnd_1
XFILLER_79_685 VGND VGND VPWR VPWR sky130_fd_sc_hd__decap_6
XFILLER_39_505 VGND VGND VPWR VPWR sky130_fd_sc_hd__decap_4
XFILLER_78_195 VGND VGND VPWR VPWR sky130_fd_sc_hd__fill_1
XFILLER_54_508 VGND VGND VPWR VPWR sky130_fd_sc_hd__decap_3
XTAP_TAPCELL_ROW_66_1044 VGND VPWR sky130_fd_sc_hd__tapvpwrvgnd_1
XFILLER_62_530 VGND VGND VPWR VPWR sky130_fd_sc_hd__fill_2
X_6870_ _alu_i0.Controller_i._present_state\[0\] _2796_ VGND VGND VPWR VPWR _0000_
+ sky130_fd_sc_hd__and2_1
XFILLER_34_232 VPWR VGND VPWR VGND sky130_ef_sc_hd__decap_12
XFILLER_62_585 VGND VGND VPWR VPWR sky130_fd_sc_hd__decap_3
XTAP_TAPCELL_ROW_17_452 VGND VPWR sky130_fd_sc_hd__tapvpwrvgnd_1
X_5821_ _1649_ _1651_ _1513_ _1516_ VGND VGND VPWR VPWR _1653_ sky130_fd_sc_hd__o211ai_2
XFILLER_34_265 VPWR VGND VPWR VGND sky130_ef_sc_hd__decap_12
X_5752_ _1349_ _1351_ _1576_ _1577_ VGND VGND VPWR VPWR _1578_ sky130_fd_sc_hd__a211oi_1
XTAP_TAPCELL_ROW_45_794 VGND VPWR sky130_fd_sc_hd__tapvpwrvgnd_1
X_4703_ _0461_ _0462_ _0393_ _0397_ VGND VGND VPWR VPWR _0465_ sky130_fd_sc_hd__o211a_1
X_5683_ net375 net368 net315 net307 VGND VGND VPWR VPWR _1502_ sky130_fd_sc_hd__nand4_1
X_4634_ _0325_ _0392_ VGND VGND VPWR VPWR _0397_ sky130_fd_sc_hd__or2_1
X_4565_ _0271_ _0327_ _0328_ VGND VGND VPWR VPWR _0329_ sky130_fd_sc_hd__or3_2
XTAP_TAPCELL_ROW_77_1173 VGND VPWR sky130_fd_sc_hd__tapvpwrvgnd_1
X_3516_ _1931_ _1942_ net124 VGND VGND VPWR VPWR _1975_ sky130_fd_sc_hd__and3_1
X_6304_ _2176_ _2177_ VGND VGND VPWR VPWR _2179_ sky130_fd_sc_hd__and2_1
X_4496_ _0260_ VGND VGND VPWR VPWR _0261_ sky130_fd_sc_hd__inv_2
XFILLER_89_438 VGND VGND VPWR VPWR sky130_fd_sc_hd__decap_8
XPHY_EDGE_ROW_4_Right_4 VGND VGND VPWR VPWR sky130_fd_sc_hd__decap_3
XFILLER_103_237 VGND VGND VPWR VPWR sky130_fd_sc_hd__decap_4
X_3447_ net130 _1212_ VGND VGND VPWR VPWR _1222_ sky130_fd_sc_hd__nand2_1
X_6235_ net116 _2102_ _1894_ _1896_ VGND VGND VPWR VPWR _2104_ sky130_fd_sc_hd__o211a_1
X_6166_ _2027_ _2026_ VGND VGND VPWR VPWR _2028_ sky130_fd_sc_hd__nand2b_1
X_5117_ _0782_ _0784_ _0882_ _0883_ VGND VGND VPWR VPWR _0886_ sky130_fd_sc_hd__a211o_1
XFILLER_57_324 VPWR VGND VPWR VGND sky130_ef_sc_hd__decap_12
X_6097_ _1951_ _1952_ VGND VGND VPWR VPWR _1954_ sky130_fd_sc_hd__xnor2_1
X_5048_ _0799_ _0809_ VGND VGND VPWR VPWR _0810_ sky130_fd_sc_hd__xnor2_1
XFILLER_84_165 VPWR VGND VPWR VGND sky130_ef_sc_hd__decap_12
XFILLER_27_69 VGND VGND VPWR VPWR sky130_fd_sc_hd__decap_8
XFILLER_80_371 VGND VGND VPWR VPWR sky130_fd_sc_hd__fill_2
XFILLER_13_449 VPWR VGND VPWR VGND sky130_ef_sc_hd__decap_12
XFILLER_43_57 VPWR VGND VPWR VGND sky130_ef_sc_hd__decap_12
XFILLER_111_3 VPWR VGND VPWR VGND sky130_ef_sc_hd__decap_12
XFILLER_5_615 VGND VGND VPWR VPWR sky130_fd_sc_hd__fill_1
XFILLER_4_29 VPWR VGND VPWR VGND sky130_ef_sc_hd__decap_12
XFILLER_0_375 VGND VGND VPWR VPWR sky130_fd_sc_hd__fill_1
XFILLER_48_335 VGND VGND VPWR VPWR sky130_fd_sc_hd__decap_4
XFILLER_75_132 VGND VGND VPWR VPWR sky130_fd_sc_hd__fill_1
XFILLER_75_165 VGND VGND VPWR VPWR sky130_fd_sc_hd__decap_3
XFILLER_63_349 VGND VGND VPWR VPWR sky130_fd_sc_hd__decap_8
XFILLER_44_530 VGND VGND VPWR VPWR sky130_fd_sc_hd__fill_2
XFILLER_71_393 VGND VGND VPWR VPWR sky130_fd_sc_hd__decap_3
XTAP_TAPCELL_ROW_14_422 VGND VPWR sky130_fd_sc_hd__tapvpwrvgnd_1
XTAP_TAPCELL_ROW_42_753 VGND VPWR sky130_fd_sc_hd__tapvpwrvgnd_1
XFILLER_8_475 VGND VGND VPWR VPWR sky130_fd_sc_hd__fill_1
XTAP_TAPCELL_ROW_113_1605 VGND VPWR sky130_fd_sc_hd__tapvpwrvgnd_1
X_4350_ _alu_i0.Datapath_i.reg_0.reg_out1\[5\] _0118_ net148 VGND VGND VPWR VPWR net104
+ sky130_fd_sc_hd__mux2_1
XFILLER_98_235 VPWR VGND VPWR VGND sky130_ef_sc_hd__decap_12
XFILLER_98_224 VGND VGND VPWR VPWR sky130_fd_sc_hd__decap_4
X_4281_ _2401_ _0051_ VGND VGND VPWR VPWR _0053_ sky130_fd_sc_hd__xnor2_1
XFILLER_4_681 VGND VGND VPWR VPWR sky130_fd_sc_hd__decap_8
XFILLER_3_180 VPWR VGND VPWR VGND sky130_ef_sc_hd__decap_12
XFILLER_67_600 VPWR VGND VPWR VGND sky130_ef_sc_hd__decap_12
X_6020_ _1867_ _1868_ VGND VGND VPWR VPWR _1869_ sky130_fd_sc_hd__xnor2_1
XFILLER_100_229 VGND VGND VPWR VPWR sky130_fd_sc_hd__fill_1
XFILLER_67_622 VPWR VGND VPWR VGND sky130_ef_sc_hd__decap_12
XFILLER_39_324 VPWR VGND VPWR VGND sky130_ef_sc_hd__decap_12
XFILLER_94_496 VGND VGND VPWR VPWR sky130_fd_sc_hd__decap_4
XFILLER_82_625 VPWR VGND VPWR VGND sky130_ef_sc_hd__decap_12
XFILLER_81_113 VGND VGND VPWR VPWR sky130_fd_sc_hd__decap_6
XFILLER_66_165 VGND VGND VPWR VPWR sky130_fd_sc_hd__decap_6
XFILLER_54_305 VGND VGND VPWR VPWR sky130_fd_sc_hd__decap_3
XFILLER_82_669 VPWR VGND VPWR VGND sky130_ef_sc_hd__decap_12
XFILLER_54_349 VPWR VGND VPWR VGND sky130_ef_sc_hd__decap_12
XFILLER_47_390 VGND VGND VPWR VPWR sky130_fd_sc_hd__fill_2
X_6853_ _2776_ _2778_ VGND VGND VPWR VPWR _2779_ sky130_fd_sc_hd__xnor2_1
X_5804_ net429 net322 VGND VGND VPWR VPWR _1634_ sky130_fd_sc_hd__nand2_1
XFILLER_50_533 VGND VGND VPWR VPWR sky130_fd_sc_hd__decap_8
X_6784_ _2355_ _2522_ _2523_ _2549_ VGND VGND VPWR VPWR _2703_ sky130_fd_sc_hd__a31o_1
XFILLER_22_268 VPWR VGND VPWR VGND sky130_ef_sc_hd__decap_12
X_3996_ net461 net293 VGND VGND VPWR VPWR _3184_ sky130_fd_sc_hd__and2_1
XFILLER_13_27 VPWR VGND VPWR VGND sky130_ef_sc_hd__decap_12
X_5735_ _1367_ _1369_ _1557_ _1558_ VGND VGND VPWR VPWR _1559_ sky130_fd_sc_hd__a211o_1
XTAP_TAPCELL_ROW_79_1202 VGND VPWR sky130_fd_sc_hd__tapvpwrvgnd_1
X_5666_ net259 net219 net186 net341 VGND VGND VPWR VPWR _1483_ sky130_fd_sc_hd__and4_1
X_4617_ _0377_ _0378_ _0371_ VGND VGND VPWR VPWR _0380_ sky130_fd_sc_hd__a21o_1
X_5597_ _1281_ _1285_ _1406_ _1407_ VGND VGND VPWR VPWR _1409_ sky130_fd_sc_hd__o211a_1
X_4548_ net407 net217 _0257_ _0256_ VGND VGND VPWR VPWR _0312_ sky130_fd_sc_hd__a31o_1
XFILLER_104_557 VPWR VGND VPWR VGND sky130_ef_sc_hd__decap_12
X_4479_ _0200_ _0202_ _0201_ VGND VGND VPWR VPWR _0244_ sky130_fd_sc_hd__a21bo_1
XFILLER_77_419 VGND VGND VPWR VPWR sky130_fd_sc_hd__decap_6
X_6218_ _1923_ _1925_ VGND VGND VPWR VPWR _2086_ sky130_fd_sc_hd__nand2_1
XFILLER_58_633 VGND VGND VPWR VPWR sky130_fd_sc_hd__decap_8
XFILLER_58_611 VGND VGND VPWR VPWR sky130_fd_sc_hd__fill_1
X_6149_ _2007_ _2009_ _1853_ _1856_ VGND VGND VPWR VPWR _2011_ sky130_fd_sc_hd__a211oi_1
XPHY_EDGE_ROW_79_Right_79 VGND VGND VPWR VPWR sky130_fd_sc_hd__decap_3
XFILLER_73_636 VPWR VGND VPWR VGND sky130_ef_sc_hd__decap_12
XFILLER_57_165 VGND VGND VPWR VPWR sky130_fd_sc_hd__decap_3
XFILLER_72_135 VGND VGND VPWR VPWR sky130_fd_sc_hd__decap_4
XFILLER_60_319 VGND VGND VPWR VPWR sky130_fd_sc_hd__decap_8
XFILLER_81_691 VGND VGND VPWR VPWR sky130_fd_sc_hd__fill_1
XFILLER_54_89 VGND VGND VPWR VPWR sky130_fd_sc_hd__fill_1
XFILLER_53_393 VPWR VGND VPWR VGND sky130_ef_sc_hd__decap_12
XFILLER_13_257 VGND VGND VPWR VPWR sky130_fd_sc_hd__decap_6
XFILLER_13_279 VGND VGND VPWR VPWR sky130_fd_sc_hd__fill_1
XPHY_EDGE_ROW_88_Right_88 VGND VGND VPWR VPWR sky130_fd_sc_hd__decap_3
XFILLER_5_412 VGND VGND VPWR VPWR sky130_fd_sc_hd__decap_4
XFILLER_5_423 VPWR VGND VPWR VGND sky130_ef_sc_hd__decap_12
XFILLER_107_373 VGND VGND VPWR VPWR sky130_fd_sc_hd__fill_2
XFILLER_95_205 VGND VGND VPWR VPWR sky130_fd_sc_hd__fill_1
XFILLER_1_673 VPWR VGND VPWR VGND sky130_ef_sc_hd__decap_12
XPHY_EDGE_ROW_97_Right_97 VGND VGND VPWR VPWR sky130_fd_sc_hd__decap_3
XFILLER_95_249 VPWR VGND VPWR VGND sky130_ef_sc_hd__decap_12
XFILLER_95_85 VGND VGND VPWR VPWR sky130_fd_sc_hd__fill_1
XFILLER_76_485 VGND VGND VPWR VPWR sky130_fd_sc_hd__decap_3
XTAP_TAPCELL_ROW_47_812 VGND VPWR sky130_fd_sc_hd__tapvpwrvgnd_1
XFILLER_64_669 VPWR VGND VPWR VGND sky130_ef_sc_hd__decap_12
XFILLER_63_113 VGND VGND VPWR VPWR sky130_fd_sc_hd__decap_8
XTAP_TAPCELL_ROW_63_1003 VGND VPWR sky130_fd_sc_hd__tapvpwrvgnd_1
XTAP_TAPCELL_ROW_27_580 VGND VPWR sky130_fd_sc_hd__tapvpwrvgnd_1
X_3850_ net133 _3026_ _3044_ net122 VGND VGND VPWR VPWR _3045_ sky130_fd_sc_hd__a22o_1
XPHY_EDGE_ROW_4_Left_121 VGND VGND VPWR VPWR sky130_fd_sc_hd__decap_3
XFILLER_32_566 VPWR VGND VPWR VGND sky130_ef_sc_hd__decap_12
X_3781_ _2259_ _2959_ _2977_ net121 _2978_ VGND VGND VPWR VPWR _2979_ sky130_fd_sc_hd__a221o_1
X_5520_ _1322_ _1323_ _1140_ _1142_ VGND VGND VPWR VPWR _1325_ sky130_fd_sc_hd__a211oi_1
X_5451_ _1130_ _1132_ _1247_ _1248_ VGND VGND VPWR VPWR _1249_ sky130_fd_sc_hd__o211ai_2
X_4402_ _0167_ _0168_ VGND VGND VPWR VPWR _0169_ sky130_fd_sc_hd__and2b_1
X_5382_ net404 net396 net307 VGND VGND VPWR VPWR _1174_ sky130_fd_sc_hd__and3_1
XFILLER_113_310 VPWR VGND VPWR VGND sky130_ef_sc_hd__decap_12
X_4333_ _0093_ _0100_ _0101_ VGND VGND VPWR VPWR _0102_ sky130_fd_sc_hd__or3_1
XTAP_TAPCELL_ROW_74_1143 VGND VPWR sky130_fd_sc_hd__tapvpwrvgnd_1
XFILLER_101_505 VPWR VGND VPWR VGND sky130_ef_sc_hd__decap_12
Xfanout229 net230 VGND VGND VPWR VPWR net229 sky130_fd_sc_hd__clkbuf_2
Xfanout207 net61 VGND VGND VPWR VPWR net207 sky130_fd_sc_hd__clkbuf_4
X_4264_ net349 net24 _1583_ _2933_ net232 VGND VGND VPWR VPWR _0039_ sky130_fd_sc_hd__a311o_1
Xfanout218 net219 VGND VGND VPWR VPWR net218 sky130_fd_sc_hd__buf_2
X_6003_ _1699_ _1701_ _1849_ _1850_ VGND VGND VPWR VPWR _1851_ sky130_fd_sc_hd__o211a_2
XFILLER_39_121 VGND VGND VPWR VPWR sky130_fd_sc_hd__fill_1
X_4195_ _3371_ _3372_ _3373_ VGND VGND VPWR VPWR _3374_ sky130_fd_sc_hd__a21oi_1
XFILLER_67_474 VPWR VGND VPWR VGND sky130_ef_sc_hd__decap_12
XFILLER_27_305 VPWR VGND VPWR VGND sky130_ef_sc_hd__decap_12
XFILLER_82_488 VPWR VGND VPWR VGND sky130_ef_sc_hd__decap_12
XFILLER_82_477 VGND VGND VPWR VPWR sky130_fd_sc_hd__fill_1
X_6905_ net182 _alu_i0.Datapath_i.fu_alu_33673_33851.out1\[31\] VGND VGND VPWR VPWR
+ _alu_i0.Datapath_i.reg_0.reg_out1\[31\] sky130_fd_sc_hd__dfxtp_1
XTAP_TAPCELL_ROW_85_1272 VGND VPWR sky130_fd_sc_hd__tapvpwrvgnd_1
XFILLER_63_691 VGND VGND VPWR VPWR sky130_fd_sc_hd__fill_1
XFILLER_24_15 VPWR VGND VPWR VGND sky130_ef_sc_hd__decap_12
XPHY_EDGE_ROW_59_Left_176 VGND VGND VPWR VPWR sky130_fd_sc_hd__decap_3
X_6836_ _2758_ _2759_ VGND VGND VPWR VPWR _2760_ sky130_fd_sc_hd__xor2_1
XFILLER_50_330 VGND VGND VPWR VPWR sky130_fd_sc_hd__decap_3
XFILLER_23_599 VPWR VGND VPWR VGND sky130_ef_sc_hd__decap_12
X_6767_ _2567_ _2568_ _2570_ VGND VGND VPWR VPWR _2685_ sky130_fd_sc_hd__a21oi_1
XFILLER_50_385 VPWR VGND VPWR VGND sky130_ef_sc_hd__decap_12
XFILLER_10_238 VPWR VGND VPWR VGND sky130_ef_sc_hd__decap_12
X_3979_ net167 _0972_ _3150_ VGND VGND VPWR VPWR _3168_ sky130_fd_sc_hd__a21oi_1
X_5718_ net441 _1540_ VGND VGND VPWR VPWR _1541_ sky130_fd_sc_hd__nand2_1
X_6698_ _2606_ _2607_ VGND VGND VPWR VPWR _2610_ sky130_fd_sc_hd__nor2_1
XFILLER_108_148 VGND VGND VPWR VPWR sky130_fd_sc_hd__decap_6
X_5649_ _1463_ _1464_ VGND VGND VPWR VPWR _1465_ sky130_fd_sc_hd__nor2_1
XFILLER_40_58 VGND VGND VPWR VPWR sky130_fd_sc_hd__decap_6
XPHY_EDGE_ROW_68_Left_185 VGND VGND VPWR VPWR sky130_fd_sc_hd__decap_3
XFILLER_104_365 VPWR VGND VPWR VGND sky130_ef_sc_hd__decap_12
XFILLER_49_45 VGND VGND VPWR VPWR sky130_fd_sc_hd__decap_8
XFILLER_105_51 VGND VGND VPWR VPWR sky130_fd_sc_hd__decap_4
XFILLER_85_271 VGND VGND VPWR VPWR sky130_fd_sc_hd__fill_1
XFILLER_65_11 VGND VGND VPWR VPWR sky130_fd_sc_hd__decap_8
XFILLER_18_305 VGND VGND VPWR VPWR sky130_fd_sc_hd__decap_3
XFILLER_65_44 VGND VGND VPWR VPWR sky130_fd_sc_hd__fill_1
XFILLER_45_113 VPWR VGND VPWR VGND sky130_ef_sc_hd__decap_12
XFILLER_46_636 VGND VGND VPWR VPWR sky130_fd_sc_hd__decap_8
XFILLER_61_617 VPWR VGND VPWR VGND sky130_ef_sc_hd__decap_12
XFILLER_46_669 VPWR VGND VPWR VGND sky130_ef_sc_hd__decap_12
XPHY_EDGE_ROW_77_Left_194 VGND VGND VPWR VPWR sky130_fd_sc_hd__decap_3
XFILLER_14_511 VGND VGND VPWR VPWR sky130_fd_sc_hd__fill_2
XFILLER_60_138 VGND VGND VPWR VPWR sky130_fd_sc_hd__fill_2
XFILLER_14_533 VPWR VGND VPWR VGND sky130_ef_sc_hd__decap_12
XTAP_TAPCELL_ROW_52_881 VGND VPWR sky130_fd_sc_hd__tapvpwrvgnd_1
XFILLER_41_352 VPWR VGND VPWR VGND sky130_ef_sc_hd__decap_12
XTAP_TAPCELL_ROW_52_870 VGND VPWR sky130_fd_sc_hd__tapvpwrvgnd_1
XFILLER_107_181 VPWR VGND VPWR VGND sky130_ef_sc_hd__decap_12
XFILLER_46_7 VPWR VGND VPWR VGND sky130_ef_sc_hd__decap_12
XFILLER_68_205 VGND VGND VPWR VPWR sky130_fd_sc_hd__fill_1
XFILLER_68_249 VGND VGND VPWR VPWR sky130_fd_sc_hd__decap_3
XFILLER_1_492 VPWR VGND VPWR VGND sky130_ef_sc_hd__decap_12
Xinput7 a[15] VGND VGND VPWR VPWR net7 sky130_fd_sc_hd__buf_1
XTAP_TAPCELL_ROW_108_1548 VGND VPWR sky130_fd_sc_hd__tapvpwrvgnd_1
XFILLER_64_444 VGND VGND VPWR VPWR sky130_fd_sc_hd__decap_6
XFILLER_64_477 VPWR VGND VPWR VGND sky130_ef_sc_hd__decap_12
XFILLER_52_617 VPWR VGND VPWR VGND sky130_ef_sc_hd__decap_12
XFILLER_36_157 VPWR VGND VPWR VGND sky130_ef_sc_hd__decap_12
X_4951_ _0624_ _0708_ VGND VGND VPWR VPWR _0709_ sky130_fd_sc_hd__and2_1
XFILLER_17_382 VGND VGND VPWR VPWR sky130_fd_sc_hd__decap_8
XFILLER_45_691 VGND VGND VPWR VPWR sky130_fd_sc_hd__fill_1
X_4882_ _0623_ _0624_ _0639_ VGND VGND VPWR VPWR _0641_ sky130_fd_sc_hd__o21ai_1
X_3902_ net176 net316 VGND VGND VPWR VPWR _3094_ sky130_fd_sc_hd__nor2_1
XFILLER_17_393 VGND VGND VPWR VPWR sky130_fd_sc_hd__decap_3
X_3833_ _3004_ _3011_ VGND VGND VPWR VPWR _3028_ sky130_fd_sc_hd__nand2_1
X_6621_ _2355_ _2524_ VGND VGND VPWR VPWR _2525_ sky130_fd_sc_hd__xor2_1
X_3764_ _2954_ _2961_ _2962_ VGND VGND VPWR VPWR _alu_i0.Datapath_i.fu_alu_33673_33851.out1\[8\]
+ sky130_fd_sc_hd__or3_1
X_6552_ _2224_ _2228_ _2225_ VGND VGND VPWR VPWR _2451_ sky130_fd_sc_hd__o21ba_1
X_3695_ _2893_ _2894_ VGND VGND VPWR VPWR _2896_ sky130_fd_sc_hd__or2_1
X_6483_ _2189_ _2191_ _2373_ VGND VGND VPWR VPWR _2375_ sky130_fd_sc_hd__nand3_1
X_5503_ _1303_ _1304_ VGND VGND VPWR VPWR _1306_ sky130_fd_sc_hd__xnor2_1
X_5434_ _1342_ _1228_ VGND VGND VPWR VPWR _1230_ sky130_fd_sc_hd__xor2_1
X_5365_ net433 net383 net187 net342 VGND VGND VPWR VPWR _1155_ sky130_fd_sc_hd__and4_1
X_4316_ _0085_ _0084_ VGND VGND VPWR VPWR _0086_ sky130_fd_sc_hd__and2b_1
X_5296_ net115 _1078_ _0973_ VGND VGND VPWR VPWR _1080_ sky130_fd_sc_hd__o21ai_1
XFILLER_101_335 VGND VGND VPWR VPWR sky130_fd_sc_hd__fill_1
XFILLER_19_15 VPWR VGND VPWR VGND sky130_ef_sc_hd__decap_12
X_4247_ net24 net22 net427 net428 net348 net277 VGND VGND VPWR VPWR _0023_ sky130_fd_sc_hd__mux4_1
XTAP_TAPCELL_ROW_87_1301 VGND VPWR sky130_fd_sc_hd__tapvpwrvgnd_1
XFILLER_28_625 VPWR VGND VPWR VGND sky130_ef_sc_hd__decap_12
X_4178_ _0885_ net255 _3337_ VGND VGND VPWR VPWR _3358_ sky130_fd_sc_hd__o21ai_1
XFILLER_27_113 VPWR VGND VPWR VGND sky130_ef_sc_hd__decap_12
XTAP_TAPCELL_ROW_2_278 VGND VPWR sky130_fd_sc_hd__tapvpwrvgnd_1
XFILLER_28_669 VPWR VGND VPWR VGND sky130_ef_sc_hd__decap_12
XFILLER_43_617 VPWR VGND VPWR VGND sky130_ef_sc_hd__decap_12
XFILLER_70_414 VGND VGND VPWR VPWR sky130_fd_sc_hd__decap_6
XFILLER_15_319 VPWR VGND VPWR VGND sky130_ef_sc_hd__decap_12
XFILLER_70_447 VPWR VGND VPWR VGND sky130_ef_sc_hd__decap_12
XFILLER_35_69 VPWR VGND VPWR VGND sky130_ef_sc_hd__decap_12
XFILLER_42_138 VGND VGND VPWR VPWR sky130_fd_sc_hd__fill_2
X_6819_ _2537_ _2538_ _2540_ VGND VGND VPWR VPWR _2742_ sky130_fd_sc_hd__a21o_1
XTAP_TAPCELL_ROW_98_1430 VGND VPWR sky130_fd_sc_hd__tapvpwrvgnd_1
XFILLER_7_529 VPWR VGND VPWR VGND sky130_ef_sc_hd__decap_12
XFILLER_105_641 VPWR VGND VPWR VGND sky130_ef_sc_hd__decap_12
XFILLER_4_3 VPWR VGND VPWR VGND sky130_ef_sc_hd__decap_12
XFILLER_105_685 VGND VGND VPWR VPWR sky130_fd_sc_hd__decap_6
XFILLER_104_162 VGND VGND VPWR VPWR sky130_fd_sc_hd__decap_8
XFILLER_78_525 VGND VGND VPWR VPWR sky130_fd_sc_hd__decap_6
XFILLER_104_195 VGND VGND VPWR VPWR sky130_fd_sc_hd__fill_1
XFILLER_93_517 VPWR VGND VPWR VGND sky130_ef_sc_hd__decap_12
XFILLER_19_614 VGND VGND VPWR VPWR sky130_fd_sc_hd__fill_2
XFILLER_18_124 VPWR VGND VPWR VGND sky130_ef_sc_hd__decap_12
XFILLER_46_433 VGND VGND VPWR VPWR sky130_fd_sc_hd__fill_2
XPHY_EDGE_ROW_85_Left_202 VGND VGND VPWR VPWR sky130_fd_sc_hd__decap_3
XFILLER_73_252 VGND VGND VPWR VPWR sky130_fd_sc_hd__decap_6
XTAP_TAPCELL_ROW_57_940 VGND VPWR sky130_fd_sc_hd__tapvpwrvgnd_1
XFILLER_33_105 VGND VGND VPWR VPWR sky130_fd_sc_hd__decap_6
XFILLER_33_127 VGND VGND VPWR VPWR sky130_fd_sc_hd__decap_4
XFILLER_46_499 VPWR VGND VPWR VGND sky130_ef_sc_hd__decap_12
XFILLER_61_458 VGND VGND VPWR VPWR sky130_fd_sc_hd__decap_8
XFILLER_27_691 VGND VGND VPWR VPWR sky130_fd_sc_hd__fill_1
XFILLER_14_352 VPWR VGND VPWR VGND sky130_ef_sc_hd__decap_12
XTAP_TAPCELL_ROW_103_1489 VGND VPWR sky130_fd_sc_hd__tapvpwrvgnd_1
XPHY_EDGE_ROW_94_Left_211 VGND VGND VPWR VPWR sky130_fd_sc_hd__decap_3
XFILLER_115_405 VPWR VGND VPWR VGND sky130_ef_sc_hd__decap_12
X_3480_ net278 net244 VGND VGND VPWR VPWR _1583_ sky130_fd_sc_hd__nor2_1
XFILLER_115_449 VPWR VGND VPWR VGND sky130_ef_sc_hd__decap_12
XTAP_TAPCELL_ROW_71_1102 VGND VPWR sky130_fd_sc_hd__tapvpwrvgnd_1
X_5150_ _0920_ VGND VGND VPWR VPWR _0921_ sky130_fd_sc_hd__inv_2
XFILLER_69_525 VGND VGND VPWR VPWR sky130_fd_sc_hd__decap_8
XFILLER_37_3 VPWR VGND VPWR VGND sky130_ef_sc_hd__decap_12
XFILLER_96_355 VGND VGND VPWR VPWR sky130_fd_sc_hd__decap_8
X_5081_ net357 net168 _0845_ VGND VGND VPWR VPWR _0846_ sky130_fd_sc_hd__and3_1
XFILLER_69_558 VGND VGND VPWR VPWR sky130_fd_sc_hd__fill_2
X_4101_ net438 net265 VGND VGND VPWR VPWR _3284_ sky130_fd_sc_hd__or2_1
XFILLER_84_506 VGND VGND VPWR VPWR sky130_fd_sc_hd__fill_1
X_4032_ net450 net461 net465 net167 net350 net279 VGND VGND VPWR VPWR _3219_ sky130_fd_sc_hd__mux4_1
XFILLER_77_580 VPWR VGND VPWR VGND sky130_ef_sc_hd__decap_12
XFILLER_2_95 VPWR VGND VPWR VGND sky130_ef_sc_hd__decap_12
XFILLER_37_411 VGND VGND VPWR VPWR sky130_fd_sc_hd__decap_8
XFILLER_49_293 VPWR VGND VPWR VGND sky130_ef_sc_hd__decap_12
XTAP_TAPCELL_ROW_69_1075 VGND VPWR sky130_fd_sc_hd__tapvpwrvgnd_1
XFILLER_25_617 VPWR VGND VPWR VGND sky130_ef_sc_hd__decap_12
X_5983_ _1827_ _1828_ _1820_ VGND VGND VPWR VPWR _1830_ sky130_fd_sc_hd__a21o_1
X_4934_ _0690_ _0691_ _0574_ _0576_ VGND VGND VPWR VPWR _0693_ sky130_fd_sc_hd__o211a_1
XTAP_TAPCELL_ROW_82_1231 VGND VPWR sky130_fd_sc_hd__tapvpwrvgnd_1
XTAP_TAPCELL_ROW_35_667 VGND VPWR sky130_fd_sc_hd__tapvpwrvgnd_1
X_4865_ net474 net457 net321 net316 VGND VGND VPWR VPWR _0624_ sky130_fd_sc_hd__and4_1
XANTENNA_12 opcode[7] VGND VGND VPWR VPWR sky130_fd_sc_hd__diode_2
XFILLER_60_491 VPWR VGND VPWR VGND sky130_ef_sc_hd__decap_12
XANTENNA_23 net197 VGND VGND VPWR VPWR sky130_fd_sc_hd__diode_2
XFILLER_32_193 VGND VGND VPWR VPWR sky130_fd_sc_hd__decap_3
X_4796_ _0552_ _0553_ _0554_ VGND VGND VPWR VPWR _0556_ sky130_fd_sc_hd__a21o_1
XANTENNA_34 net402 VGND VGND VPWR VPWR sky130_fd_sc_hd__diode_2
X_3816_ _2986_ _3005_ _1887_ VGND VGND VPWR VPWR _3012_ sky130_fd_sc_hd__a21oi_1
X_6604_ _2504_ _2505_ VGND VGND VPWR VPWR _2506_ sky130_fd_sc_hd__or2_1
X_3747_ _2920_ _2924_ _2918_ VGND VGND VPWR VPWR _2946_ sky130_fd_sc_hd__a21o_1
XFILLER_21_27 VPWR VGND VPWR VGND sky130_ef_sc_hd__decap_12
X_6535_ net234 net222 net436 net435 VGND VGND VPWR VPWR _2432_ sky130_fd_sc_hd__and4_1
X_3678_ _1070_ _2871_ _2877_ _2879_ net130 VGND VGND VPWR VPWR _2880_ sky130_fd_sc_hd__o221a_1
X_6466_ _2342_ _2354_ VGND VGND VPWR VPWR _2356_ sky130_fd_sc_hd__xor2_1
X_5417_ _1210_ _1211_ VGND VGND VPWR VPWR _1213_ sky130_fd_sc_hd__or2_1
X_6397_ _2172_ _2279_ VGND VGND VPWR VPWR _2282_ sky130_fd_sc_hd__xor2_1
XTAP_TAPCELL_ROW_93_1371 VGND VPWR sky130_fd_sc_hd__tapvpwrvgnd_1
X_5348_ _1133_ _1134_ _1025_ _1028_ VGND VGND VPWR VPWR _1137_ sky130_fd_sc_hd__a211o_1
XTAP_TAPCELL_ROW_7_337 VGND VPWR sky130_fd_sc_hd__tapvpwrvgnd_1
XFILLER_75_517 VPWR VGND VPWR VGND sky130_ef_sc_hd__decap_12
X_5279_ net412 net404 net317 net308 VGND VGND VPWR VPWR _1062_ sky130_fd_sc_hd__nand4_1
XFILLER_28_433 VPWR VGND VPWR VGND sky130_ef_sc_hd__decap_12
XFILLER_28_477 VGND VGND VPWR VPWR sky130_fd_sc_hd__decap_6
XFILLER_43_403 VPWR VGND VPWR VGND sky130_ef_sc_hd__decap_12
XFILLER_102_41 VPWR VGND VPWR VGND sky130_ef_sc_hd__decap_12
XFILLER_43_447 VGND VGND VPWR VPWR sky130_fd_sc_hd__fill_1
XFILLER_62_45 VGND VGND VPWR VPWR sky130_fd_sc_hd__decap_4
XFILLER_70_288 VGND VGND VPWR VPWR sky130_fd_sc_hd__decap_8
XFILLER_62_89 VGND VGND VPWR VPWR sky130_fd_sc_hd__decap_8
XFILLER_62_56 VPWR VGND VPWR VGND sky130_ef_sc_hd__decap_12
XFILLER_23_182 VPWR VGND VPWR VGND sky130_ef_sc_hd__decap_12
XFILLER_11_366 VGND VGND VPWR VPWR sky130_fd_sc_hd__fill_2
XFILLER_7_337 VPWR VGND VPWR VGND sky130_ef_sc_hd__decap_12
XFILLER_112_419 VGND VGND VPWR VPWR sky130_fd_sc_hd__fill_1
XFILLER_87_64 VGND VGND VPWR VPWR sky130_fd_sc_hd__decap_8
XFILLER_93_314 VPWR VGND VPWR VGND sky130_ef_sc_hd__decap_12
Xfanout390 net29 VGND VGND VPWR VPWR net390 sky130_fd_sc_hd__clkbuf_4
XFILLER_19_400 VGND VGND VPWR VPWR sky130_fd_sc_hd__decap_3
XTAP_TAPCELL_ROW_105_1507 VGND VPWR sky130_fd_sc_hd__tapvpwrvgnd_1
XFILLER_19_477 VGND VGND VPWR VPWR sky130_fd_sc_hd__fill_1
XFILLER_61_222 VGND VGND VPWR VPWR sky130_fd_sc_hd__fill_2
XTAP_TAPCELL_ROW_32_637 VGND VPWR sky130_fd_sc_hd__tapvpwrvgnd_1
X_4650_ _0408_ _0411_ VGND VGND VPWR VPWR _0412_ sky130_fd_sc_hd__xnor2_1
XTAP_TAPCELL_ROW_60_968 VGND VPWR sky130_fd_sc_hd__tapvpwrvgnd_1
XFILLER_14_193 VGND VGND VPWR VPWR sky130_fd_sc_hd__decap_3
X_3601_ net239 net414 VGND VGND VPWR VPWR _2805_ sky130_fd_sc_hd__and2_1
Xinput10 a[18] VGND VGND VPWR VPWR net10 sky130_fd_sc_hd__buf_1
Xinput21 a[28] VGND VGND VPWR VPWR net21 sky130_fd_sc_hd__clkbuf_2
X_4581_ net457 net424 net189 net344 VGND VGND VPWR VPWR _0344_ sky130_fd_sc_hd__and4_1
XTAP_TAPCELL_ROW_12_394 VGND VPWR sky130_fd_sc_hd__tapvpwrvgnd_1
X_6320_ _2031_ _2195_ VGND VGND VPWR VPWR _2197_ sky130_fd_sc_hd__xor2_1
Xinput32 a[9] VGND VGND VPWR VPWR net32 sky130_fd_sc_hd__clkbuf_1
Xinput43 b[19] VGND VGND VPWR VPWR net43 sky130_fd_sc_hd__clkbuf_1
Xinput54 b[29] VGND VGND VPWR VPWR net54 sky130_fd_sc_hd__buf_2
XTAP_TAPCELL_ROW_116_1658 VGND VPWR sky130_fd_sc_hd__tapvpwrvgnd_1
XTAP_TAPCELL_ROW_116_1647 VGND VPWR sky130_fd_sc_hd__tapvpwrvgnd_1
Xinput65 clock VGND VGND VPWR VPWR net65 sky130_fd_sc_hd__clkbuf_1
X_3532_ net347 net435 VGND VGND VPWR VPWR _2150_ sky130_fd_sc_hd__nand2_2
XFILLER_89_609 VGND VGND VPWR VPWR sky130_fd_sc_hd__decap_6
X_3463_ _1332_ _1386_ net246 VGND VGND VPWR VPWR _1397_ sky130_fd_sc_hd__mux2_1
X_6251_ net283 net19 _2120_ VGND VGND VPWR VPWR _2122_ sky130_fd_sc_hd__a21o_1
X_5202_ _0934_ _0935_ _0976_ VGND VGND VPWR VPWR _0978_ sky130_fd_sc_hd__a21o_1
X_6182_ net397 net390 net271 net268 VGND VGND VPWR VPWR _2046_ sky130_fd_sc_hd__and4_1
XFILLER_97_653 VPWR VGND VPWR VGND sky130_ef_sc_hd__decap_12
X_5133_ _0891_ _0901_ VGND VGND VPWR VPWR _0902_ sky130_fd_sc_hd__xnor2_1
XFILLER_69_333 VGND VGND VPWR VPWR sky130_fd_sc_hd__decap_3
XFILLER_111_441 VGND VGND VPWR VPWR sky130_fd_sc_hd__decap_6
XFILLER_69_355 VPWR VGND VPWR VGND sky130_ef_sc_hd__decap_12
X_5064_ _0793_ _0826_ VGND VGND VPWR VPWR _0827_ sky130_fd_sc_hd__or2_1
X_4015_ _3162_ _3185_ VGND VGND VPWR VPWR _3202_ sky130_fd_sc_hd__nand2_1
XFILLER_65_561 VGND VGND VPWR VPWR sky130_fd_sc_hd__decap_6
XFILLER_16_27 VGND VGND VPWR VPWR sky130_fd_sc_hd__fill_1
XFILLER_25_436 VPWR VGND VPWR VGND sky130_ef_sc_hd__decap_12
XFILLER_80_586 VGND VGND VPWR VPWR sky130_fd_sc_hd__fill_2
XFILLER_13_609 VGND VGND VPWR VPWR sky130_fd_sc_hd__decap_6
X_5966_ _1809_ _1810_ VGND VGND VPWR VPWR _1811_ sky130_fd_sc_hd__xor2_1
XFILLER_52_277 VPWR VGND VPWR VGND sky130_ef_sc_hd__decap_12
X_4917_ _0590_ _0593_ _0674_ _0675_ VGND VGND VPWR VPWR _0676_ sky130_fd_sc_hd__a211o_1
X_5897_ net411 net403 net272 net269 VGND VGND VPWR VPWR _1736_ sky130_fd_sc_hd__and4_1
X_4848_ _0525_ _0605_ _0606_ VGND VGND VPWR VPWR _0608_ sky130_fd_sc_hd__and3_1
XFILLER_20_141 VGND VGND VPWR VPWR sky130_fd_sc_hd__decap_8
XFILLER_21_653 VPWR VGND VPWR VGND sky130_ef_sc_hd__decap_12
XFILLER_32_15 VPWR VGND VPWR VGND sky130_ef_sc_hd__decap_12
X_4779_ _0537_ _0539_ VGND VGND VPWR VPWR _0540_ sky130_fd_sc_hd__or2_1
X_6518_ _2403_ _2411_ VGND VGND VPWR VPWR _2414_ sky130_fd_sc_hd__nand2_1
X_6449_ _2336_ _2337_ VGND VGND VPWR VPWR _2338_ sky130_fd_sc_hd__nor2_1
XFILLER_0_557 VGND VGND VPWR VPWR sky130_fd_sc_hd__decap_3
XFILLER_113_51 VGND VGND VPWR VPWR sky130_fd_sc_hd__decap_4
XFILLER_83_391 VGND VGND VPWR VPWR sky130_fd_sc_hd__fill_1
XFILLER_71_531 VGND VGND VPWR VPWR sky130_fd_sc_hd__decap_4
XFILLER_43_277 VGND VGND VPWR VPWR sky130_fd_sc_hd__decap_3
XTAP_TAPCELL_ROW_100_1448 VGND VPWR sky130_fd_sc_hd__tapvpwrvgnd_1
XFILLER_11_130 VGND VGND VPWR VPWR sky130_fd_sc_hd__decap_8
XFILLER_8_613 VPWR VGND VPWR VGND sky130_ef_sc_hd__decap_12
XFILLER_8_657 VPWR VGND VPWR VGND sky130_ef_sc_hd__decap_12
XFILLER_7_156 VPWR VGND VPWR VGND sky130_ef_sc_hd__decap_12
XFILLER_98_41 VPWR VGND VPWR VGND sky130_ef_sc_hd__decap_12
XFILLER_98_417 VGND VGND VPWR VPWR sky130_fd_sc_hd__decap_3
XFILLER_98_85 VGND VGND VPWR VPWR sky130_fd_sc_hd__decap_3
XFILLER_98_63 VGND VGND VPWR VPWR sky130_fd_sc_hd__fill_2
XTAP_TAPCELL_ROW_111_1588 VGND VPWR sky130_fd_sc_hd__tapvpwrvgnd_1
XFILLER_94_601 VPWR VGND VPWR VGND sky130_ef_sc_hd__decap_12
XFILLER_79_653 VPWR VGND VPWR VGND sky130_ef_sc_hd__decap_12
XFILLER_78_141 VGND VGND VPWR VPWR sky130_fd_sc_hd__decap_4
XFILLER_94_645 VPWR VGND VPWR VGND sky130_ef_sc_hd__decap_12
XFILLER_93_111 VGND VGND VPWR VPWR sky130_fd_sc_hd__fill_1
XFILLER_66_336 VGND VGND VPWR VPWR sky130_fd_sc_hd__decap_3
XFILLER_66_314 VPWR VGND VPWR VGND sky130_ef_sc_hd__decap_12
XFILLER_94_689 VGND VGND VPWR VPWR sky130_fd_sc_hd__decap_3
XFILLER_81_306 VGND VGND VPWR VPWR sky130_fd_sc_hd__fill_1
XFILLER_47_561 VPWR VGND VPWR VGND sky130_ef_sc_hd__decap_12
XFILLER_74_380 VGND VGND VPWR VPWR sky130_fd_sc_hd__fill_1
XTAP_TAPCELL_ROW_66_1045 VGND VPWR sky130_fd_sc_hd__tapvpwrvgnd_1
XFILLER_62_553 VPWR VGND VPWR VGND sky130_ef_sc_hd__decap_12
XTAP_TAPCELL_ROW_17_453 VGND VPWR sky130_fd_sc_hd__tapvpwrvgnd_1
X_5820_ _1513_ _1516_ _1649_ _1651_ VGND VGND VPWR VPWR _1652_ sky130_fd_sc_hd__a211o_2
XFILLER_34_244 VGND VGND VPWR VPWR sky130_fd_sc_hd__decap_8
X_5751_ _1574_ _1575_ _1442_ _1444_ VGND VGND VPWR VPWR _1577_ sky130_fd_sc_hd__o211a_1
XPHY_EDGE_ROW_22_Left_139 VGND VGND VPWR VPWR sky130_fd_sc_hd__decap_3
XFILLER_34_277 VPWR VGND VPWR VGND sky130_ef_sc_hd__decap_12
XTAP_TAPCELL_ROW_45_795 VGND VPWR sky130_fd_sc_hd__tapvpwrvgnd_1
X_4702_ _0393_ _0397_ _0461_ _0462_ VGND VGND VPWR VPWR _0464_ sky130_fd_sc_hd__a211o_1
X_5682_ _1387_ _1390_ _1388_ VGND VGND VPWR VPWR _1501_ sky130_fd_sc_hd__o21bai_1
XFILLER_30_472 VGND VGND VPWR VPWR sky130_fd_sc_hd__decap_4
X_4633_ _0325_ _0392_ VGND VGND VPWR VPWR _0396_ sky130_fd_sc_hd__nor2_1
XFILLER_8_83 VGND VGND VPWR VPWR sky130_fd_sc_hd__fill_1
X_4564_ _0325_ _0326_ _0294_ VGND VGND VPWR VPWR _0328_ sky130_fd_sc_hd__a21oi_1
XFILLER_116_555 VGND VGND VPWR VPWR sky130_fd_sc_hd__decap_4
XFILLER_116_533 VGND VGND VPWR VPWR sky130_fd_sc_hd__decap_4
XTAP_TAPCELL_ROW_77_1174 VGND VPWR sky130_fd_sc_hd__tapvpwrvgnd_1
X_3515_ _1113_ net67 net66 VGND VGND VPWR VPWR _1964_ sky130_fd_sc_hd__or3b_1
X_6303_ _2176_ _2177_ VGND VGND VPWR VPWR _2178_ sky130_fd_sc_hd__nor2_1
X_4495_ _0254_ _0259_ VGND VGND VPWR VPWR _0260_ sky130_fd_sc_hd__and2_1
XFILLER_89_428 VGND VGND VPWR VPWR sky130_fd_sc_hd__decap_3
X_6234_ _1894_ _1896_ net116 _2102_ VGND VGND VPWR VPWR _2103_ sky130_fd_sc_hd__a211oi_4
XPHY_EDGE_ROW_31_Left_148 VGND VGND VPWR VPWR sky130_fd_sc_hd__decap_3
XTAP_TAPCELL_ROW_90_1330 VGND VPWR sky130_fd_sc_hd__tapvpwrvgnd_1
X_3446_ net67 _1113_ VGND VGND VPWR VPWR _1212_ sky130_fd_sc_hd__or2_1
XFILLER_97_461 VGND VGND VPWR VPWR sky130_fd_sc_hd__decap_4
X_6165_ _1866_ _1868_ _1864_ VGND VGND VPWR VPWR _2027_ sky130_fd_sc_hd__o21ba_1
XFILLER_111_271 VGND VGND VPWR VPWR sky130_fd_sc_hd__decap_8
XFILLER_111_260 VGND VGND VPWR VPWR sky130_fd_sc_hd__decap_8
X_5116_ _0882_ _0883_ _0782_ _0784_ VGND VGND VPWR VPWR _0884_ sky130_fd_sc_hd__o211a_1
X_6096_ net247 net439 VGND VGND VPWR VPWR _1952_ sky130_fd_sc_hd__nand2_1
X_5047_ _0806_ _0807_ VGND VGND VPWR VPWR _0809_ sky130_fd_sc_hd__and2b_1
XFILLER_27_15 VPWR VGND VPWR VGND sky130_ef_sc_hd__decap_12
XFILLER_84_177 VPWR VGND VPWR VGND sky130_ef_sc_hd__decap_12
XFILLER_72_317 VGND VGND VPWR VPWR sky130_fd_sc_hd__fill_2
XFILLER_72_306 VGND VGND VPWR VPWR sky130_fd_sc_hd__fill_2
XFILLER_53_531 VGND VGND VPWR VPWR sky130_fd_sc_hd__fill_2
XFILLER_25_211 VGND VGND VPWR VPWR sky130_fd_sc_hd__fill_2
XPHY_EDGE_ROW_40_Left_157 VGND VGND VPWR VPWR sky130_fd_sc_hd__decap_3
X_5949_ _1788_ _1789_ _1608_ VGND VGND VPWR VPWR _1793_ sky130_fd_sc_hd__a21oi_1
XFILLER_25_277 VGND VGND VPWR VPWR sky130_fd_sc_hd__decap_3
XFILLER_43_69 VGND VGND VPWR VPWR sky130_fd_sc_hd__decap_8
XFILLER_104_3 VPWR VGND VPWR VGND sky130_ef_sc_hd__decap_12
XFILLER_0_321 VGND VGND VPWR VPWR sky130_fd_sc_hd__decap_8
XFILLER_75_111 VGND VGND VPWR VPWR sky130_fd_sc_hd__fill_1
XFILLER_48_314 VGND VGND VPWR VPWR sky130_fd_sc_hd__fill_2
XFILLER_102_293 VPWR VGND VPWR VGND sky130_ef_sc_hd__decap_12
XFILLER_76_645 VPWR VGND VPWR VGND sky130_ef_sc_hd__decap_12
XFILLER_48_347 VGND VGND VPWR VPWR sky130_fd_sc_hd__fill_1
XFILLER_76_689 VGND VGND VPWR VPWR sky130_fd_sc_hd__decap_3
XFILLER_29_561 VPWR VGND VPWR VGND sky130_ef_sc_hd__decap_12
XFILLER_75_199 VGND VGND VPWR VPWR sky130_fd_sc_hd__decap_3
XFILLER_56_380 VGND VGND VPWR VPWR sky130_fd_sc_hd__fill_1
XFILLER_44_520 VGND VGND VPWR VPWR sky130_fd_sc_hd__fill_2
XFILLER_17_81 VGND VGND VPWR VPWR sky130_fd_sc_hd__fill_1
XFILLER_71_372 VGND VGND VPWR VPWR sky130_fd_sc_hd__fill_1
XFILLER_31_225 VPWR VGND VPWR VGND sky130_ef_sc_hd__decap_12
XTAP_TAPCELL_ROW_14_423 VGND VPWR sky130_fd_sc_hd__tapvpwrvgnd_1
XFILLER_31_258 VGND VGND VPWR VPWR sky130_fd_sc_hd__decap_3
XTAP_TAPCELL_ROW_42_754 VGND VPWR sky130_fd_sc_hd__tapvpwrvgnd_1
XFILLER_8_421 VPWR VGND VPWR VGND sky130_ef_sc_hd__decap_12
XFILLER_8_410 VGND VGND VPWR VPWR sky130_fd_sc_hd__decap_8
XTAP_TAPCELL_ROW_113_1606 VGND VPWR sky130_fd_sc_hd__tapvpwrvgnd_1
XFILLER_113_503 VGND VGND VPWR VPWR sky130_fd_sc_hd__fill_1
XFILLER_98_247 VGND VGND VPWR VPWR sky130_fd_sc_hd__decap_4
X_4280_ net354 net422 _0051_ VGND VGND VPWR VPWR _0052_ sky130_fd_sc_hd__and3_1
XFILLER_79_461 VGND VGND VPWR VPWR sky130_fd_sc_hd__fill_1
XFILLER_3_192 VGND VGND VPWR VPWR sky130_fd_sc_hd__decap_4
XFILLER_67_634 VPWR VGND VPWR VGND sky130_ef_sc_hd__decap_12
XFILLER_67_612 VGND VGND VPWR VPWR sky130_fd_sc_hd__decap_4
XFILLER_94_475 VGND VGND VPWR VPWR sky130_fd_sc_hd__fill_1
XFILLER_82_637 VGND VGND VPWR VPWR sky130_fd_sc_hd__decap_6
XFILLER_81_125 VGND VGND VPWR VPWR sky130_fd_sc_hd__fill_2
XFILLER_81_158 VGND VGND VPWR VPWR sky130_fd_sc_hd__decap_4
X_6852_ _2544_ _2547_ VGND VGND VPWR VPWR _2778_ sky130_fd_sc_hd__nor2_1
XFILLER_90_681 VGND VGND VPWR VPWR sky130_fd_sc_hd__decap_8
X_5803_ net360 net315 net307 net368 VGND VGND VPWR VPWR _1633_ sky130_fd_sc_hd__a22o_1
X_6783_ _2671_ _2701_ VGND VGND VPWR VPWR _2702_ sky130_fd_sc_hd__xnor2_1
X_3995_ _3182_ VGND VGND VPWR VPWR _3183_ sky130_fd_sc_hd__inv_2
XFILLER_13_39 VPWR VGND VPWR VGND sky130_ef_sc_hd__decap_12
X_5734_ _1555_ _1556_ _1361_ _1365_ VGND VGND VPWR VPWR _1558_ sky130_fd_sc_hd__o211a_1
XFILLER_50_589 VPWR VGND VPWR VGND sky130_ef_sc_hd__decap_12
XTAP_TAPCELL_ROW_79_1203 VGND VPWR sky130_fd_sc_hd__tapvpwrvgnd_1
X_5665_ _1480_ _1481_ VGND VGND VPWR VPWR _1482_ sky130_fd_sc_hd__and2_1
X_4616_ _0371_ _0377_ _0378_ VGND VGND VPWR VPWR _0379_ sky130_fd_sc_hd__nand3_1
XPHY_EDGE_ROW_111_Right_111 VGND VGND VPWR VPWR sky130_fd_sc_hd__decap_3
X_5596_ _3004_ _1403_ _1405_ VGND VGND VPWR VPWR _1407_ sky130_fd_sc_hd__or3b_1
XFILLER_104_503 VPWR VGND VPWR VGND sky130_ef_sc_hd__decap_12
X_4547_ net357 net431 _0308_ _0309_ VGND VGND VPWR VPWR _0311_ sky130_fd_sc_hd__nand4_2
XFILLER_116_396 VGND VGND VPWR VPWR sky130_fd_sc_hd__fill_1
X_4478_ _0239_ _0240_ _0241_ VGND VGND VPWR VPWR _0243_ sky130_fd_sc_hd__nand3_1
XFILLER_89_225 VGND VGND VPWR VPWR sky130_fd_sc_hd__decap_6
XFILLER_104_569 VPWR VGND VPWR VGND sky130_ef_sc_hd__decap_12
X_3429_ net69 _1015_ VGND VGND VPWR VPWR _1026_ sky130_fd_sc_hd__nor2_1
X_6217_ _2082_ _2083_ VGND VGND VPWR VPWR _2085_ sky130_fd_sc_hd__or2_1
X_6148_ _1853_ _1856_ _2007_ _2009_ VGND VGND VPWR VPWR _2010_ sky130_fd_sc_hd__o211a_1
XFILLER_85_442 VGND VGND VPWR VPWR sky130_fd_sc_hd__decap_6
XFILLER_58_645 VPWR VGND VPWR VGND sky130_ef_sc_hd__decap_12
XFILLER_57_122 VGND VGND VPWR VPWR sky130_fd_sc_hd__fill_1
XFILLER_58_689 VGND VGND VPWR VPWR sky130_fd_sc_hd__decap_3
X_6079_ _1929_ _1930_ _1932_ VGND VGND VPWR VPWR _1934_ sky130_fd_sc_hd__nand3_2
XFILLER_73_648 VPWR VGND VPWR VGND sky130_ef_sc_hd__decap_12
XFILLER_72_158 VPWR VGND VPWR VGND sky130_ef_sc_hd__decap_12
XFILLER_13_225 VPWR VGND VPWR VGND sky130_ef_sc_hd__decap_12
XFILLER_110_41 VPWR VGND VPWR VGND sky130_ef_sc_hd__decap_12
XFILLER_110_85 VGND VGND VPWR VPWR sky130_fd_sc_hd__decap_6
XFILLER_5_435 VPWR VGND VPWR VGND sky130_ef_sc_hd__decap_12
XFILLER_1_641 VPWR VGND VPWR VGND sky130_ef_sc_hd__decap_12
XFILLER_95_217 VGND VGND VPWR VPWR sky130_fd_sc_hd__decap_6
XFILLER_1_685 VGND VGND VPWR VPWR sky130_fd_sc_hd__decap_6
XFILLER_76_475 VGND VGND VPWR VPWR sky130_fd_sc_hd__fill_1
XFILLER_36_306 VGND VGND VPWR VPWR sky130_fd_sc_hd__fill_2
XTAP_TAPCELL_ROW_47_813 VGND VPWR sky130_fd_sc_hd__tapvpwrvgnd_1
XFILLER_63_125 VPWR VGND VPWR VGND sky130_ef_sc_hd__decap_12
XFILLER_17_520 VPWR VGND VPWR VGND sky130_ef_sc_hd__decap_12
XFILLER_91_456 VGND VGND VPWR VPWR sky130_fd_sc_hd__decap_8
XFILLER_63_147 VPWR VGND VPWR VGND sky130_ef_sc_hd__decap_12
XFILLER_72_681 VGND VGND VPWR VPWR sky130_fd_sc_hd__decap_8
XTAP_TAPCELL_ROW_63_1004 VGND VPWR sky130_fd_sc_hd__tapvpwrvgnd_1
XTAP_TAPCELL_ROW_27_570 VGND VPWR sky130_fd_sc_hd__tapvpwrvgnd_1
XTAP_TAPCELL_ROW_27_581 VGND VPWR sky130_fd_sc_hd__tapvpwrvgnd_1
X_3780_ net137 _2964_ _2965_ net133 VGND VGND VPWR VPWR _2978_ sky130_fd_sc_hd__a22o_1
XFILLER_32_578 VGND VGND VPWR VPWR sky130_fd_sc_hd__decap_8
XFILLER_32_589 VPWR VGND VPWR VGND sky130_ef_sc_hd__decap_12
X_5450_ _1243_ _1245_ _1126_ _1129_ VGND VGND VPWR VPWR _1248_ sky130_fd_sc_hd__o211ai_2
X_4401_ _0164_ _0165_ _0166_ VGND VGND VPWR VPWR _0168_ sky130_fd_sc_hd__a21o_1
XFILLER_67_3 VPWR VGND VPWR VGND sky130_ef_sc_hd__decap_12
X_5381_ net396 net315 net307 net404 VGND VGND VPWR VPWR _1173_ sky130_fd_sc_hd__a22o_1
XFILLER_113_322 VPWR VGND VPWR VGND sky130_ef_sc_hd__decap_12
X_4332_ _0097_ _0098_ _0099_ VGND VGND VPWR VPWR _0101_ sky130_fd_sc_hd__a21oi_1
XTAP_TAPCELL_ROW_74_1144 VGND VPWR sky130_fd_sc_hd__tapvpwrvgnd_1
XFILLER_5_51 VGND VGND VPWR VPWR sky130_fd_sc_hd__decap_4
Xfanout208 net209 VGND VGND VPWR VPWR net208 sky130_fd_sc_hd__buf_2
X_4263_ net245 _3363_ VGND VGND VPWR VPWR _0038_ sky130_fd_sc_hd__and2_1
Xfanout219 net6 VGND VGND VPWR VPWR net219 sky130_fd_sc_hd__clkbuf_4
XPHY_EDGE_ROW_105_Left_222 VGND VGND VPWR VPWR sky130_fd_sc_hd__decap_3
XFILLER_101_517 VGND VGND VPWR VPWR sky130_fd_sc_hd__decap_8
X_6002_ _1846_ _1847_ _1656_ net110 VGND VGND VPWR VPWR _1850_ sky130_fd_sc_hd__a211o_1
X_4194_ _3371_ _3372_ net125 VGND VGND VPWR VPWR _3373_ sky130_fd_sc_hd__o21ai_1
XFILLER_67_486 VPWR VGND VPWR VGND sky130_ef_sc_hd__decap_12
XFILLER_55_615 VGND VGND VPWR VPWR sky130_fd_sc_hd__fill_1
XFILLER_27_317 VGND VGND VPWR VPWR sky130_fd_sc_hd__decap_8
XFILLER_82_412 VGND VGND VPWR VPWR sky130_fd_sc_hd__decap_8
XFILLER_54_136 VGND VGND VPWR VPWR sky130_fd_sc_hd__decap_4
X_6904_ net182 _alu_i0.Datapath_i.fu_alu_33673_33851.out1\[30\] VGND VGND VPWR VPWR
+ _alu_i0.Datapath_i.reg_0.reg_out1\[30\] sky130_fd_sc_hd__dfxtp_1
XFILLER_54_169 VGND VGND VPWR VPWR sky130_fd_sc_hd__fill_2
XFILLER_42_309 VPWR VGND VPWR VGND sky130_ef_sc_hd__decap_12
XTAP_TAPCELL_ROW_85_1273 VGND VPWR sky130_fd_sc_hd__tapvpwrvgnd_1
XFILLER_23_501 VGND VGND VPWR VPWR sky130_fd_sc_hd__decap_3
XFILLER_62_191 VGND VGND VPWR VPWR sky130_fd_sc_hd__decap_4
XFILLER_24_27 VGND VGND VPWR VPWR sky130_fd_sc_hd__fill_1
X_6835_ net441 net193 VGND VGND VPWR VPWR _2759_ sky130_fd_sc_hd__nand2_1
XPHY_EDGE_ROW_114_Left_231 VGND VGND VPWR VPWR sky130_fd_sc_hd__decap_3
X_6766_ _1484_ _2682_ VGND VGND VPWR VPWR _2683_ sky130_fd_sc_hd__xor2_1
X_3978_ net142 _3161_ net135 VGND VGND VPWR VPWR _3167_ sky130_fd_sc_hd__o21ai_1
X_5717_ _1537_ _1538_ VGND VGND VPWR VPWR _1540_ sky130_fd_sc_hd__xor2_2
XFILLER_50_397 VPWR VGND VPWR VGND sky130_ef_sc_hd__decap_12
XFILLER_109_617 VPWR VGND VPWR VGND sky130_ef_sc_hd__decap_12
X_6697_ _2606_ _2607_ VGND VGND VPWR VPWR _2609_ sky130_fd_sc_hd__and2_1
X_5648_ net420 net272 net269 net453 VGND VGND VPWR VPWR _1464_ sky130_fd_sc_hd__a22oi_1
X_5579_ _1387_ _1388_ VGND VGND VPWR VPWR _1389_ sky130_fd_sc_hd__nor2_1
XFILLER_2_427 VGND VGND VPWR VPWR sky130_fd_sc_hd__fill_1
XFILLER_116_193 VGND VGND VPWR VPWR sky130_fd_sc_hd__decap_3
XFILLER_104_377 VPWR VGND VPWR VGND sky130_ef_sc_hd__decap_12
XFILLER_49_57 VGND VGND VPWR VPWR sky130_fd_sc_hd__fill_1
XFILLER_58_475 VGND VGND VPWR VPWR sky130_fd_sc_hd__fill_1
XFILLER_18_317 VGND VGND VPWR VPWR sky130_fd_sc_hd__fill_1
XFILLER_45_125 VPWR VGND VPWR VGND sky130_ef_sc_hd__decap_12
XFILLER_73_489 VGND VGND VPWR VPWR sky130_fd_sc_hd__decap_8
XFILLER_61_629 VPWR VGND VPWR VGND sky130_ef_sc_hd__decap_12
XFILLER_54_681 VGND VGND VPWR VPWR sky130_fd_sc_hd__decap_4
XFILLER_14_545 VPWR VGND VPWR VGND sky130_ef_sc_hd__decap_12
XFILLER_81_55 VGND VGND VPWR VPWR sky130_fd_sc_hd__fill_1
XFILLER_14_589 VPWR VGND VPWR VGND sky130_ef_sc_hd__decap_12
XTAP_TAPCELL_ROW_24_540 VGND VPWR sky130_fd_sc_hd__tapvpwrvgnd_1
XFILLER_41_364 VPWR VGND VPWR VGND sky130_ef_sc_hd__decap_12
XTAP_TAPCELL_ROW_52_871 VGND VPWR sky130_fd_sc_hd__tapvpwrvgnd_1
XFILLER_14_93 VGND VGND VPWR VPWR sky130_fd_sc_hd__decap_3
XFILLER_115_609 VGND VGND VPWR VPWR sky130_fd_sc_hd__decap_6
XFILLER_53_9 VPWR VGND VPWR VGND sky130_ef_sc_hd__decap_12
XFILLER_107_193 VPWR VGND VPWR VGND sky130_ef_sc_hd__decap_12
XFILLER_96_559 VPWR VGND VPWR VGND sky130_ef_sc_hd__decap_12
XFILLER_96_548 VGND VGND VPWR VPWR sky130_fd_sc_hd__fill_2
Xinput8 a[16] VGND VGND VPWR VPWR net8 sky130_fd_sc_hd__buf_1
XFILLER_37_615 VGND VGND VPWR VPWR sky130_fd_sc_hd__fill_1
XTAP_TAPCELL_ROW_108_1549 VGND VPWR sky130_fd_sc_hd__tapvpwrvgnd_1
XFILLER_36_169 VGND VGND VPWR VPWR sky130_fd_sc_hd__decap_4
X_4950_ _0706_ _0707_ VGND VGND VPWR VPWR _0708_ sky130_fd_sc_hd__xnor2_1
XFILLER_64_489 VPWR VGND VPWR VGND sky130_ef_sc_hd__decap_12
XFILLER_52_629 VPWR VGND VPWR VGND sky130_ef_sc_hd__decap_12
X_4881_ _0623_ _0624_ _0639_ VGND VGND VPWR VPWR _0640_ sky130_fd_sc_hd__or3_1
X_3901_ _3072_ _3078_ VGND VGND VPWR VPWR _3093_ sky130_fd_sc_hd__nand2_1
XFILLER_32_320 VGND VGND VPWR VPWR sky130_fd_sc_hd__decap_3
X_3832_ _3024_ _3025_ VGND VGND VPWR VPWR _3027_ sky130_fd_sc_hd__or2_1
X_6620_ _2522_ _2523_ VGND VGND VPWR VPWR _2524_ sky130_fd_sc_hd__nand2_1
X_6551_ _2285_ _2288_ _2286_ VGND VGND VPWR VPWR _2450_ sky130_fd_sc_hd__o21ba_1
X_3763_ net119 _2955_ _2959_ _1517_ VGND VGND VPWR VPWR _2962_ sky130_fd_sc_hd__a22o_1
X_5502_ _1303_ _1304_ VGND VGND VPWR VPWR _1305_ sky130_fd_sc_hd__or2_1
X_3694_ _2893_ _2894_ VGND VGND VPWR VPWR _2895_ sky130_fd_sc_hd__nor2_1
X_6482_ _2189_ _2191_ _2373_ VGND VGND VPWR VPWR _2374_ sky130_fd_sc_hd__a21o_1
X_5433_ _1342_ _1228_ VGND VGND VPWR VPWR _1229_ sky130_fd_sc_hd__or2_1
X_5364_ net383 net187 net342 net433 VGND VGND VPWR VPWR _1154_ sky130_fd_sc_hd__a22o_1
XFILLER_10_29 VPWR VGND VPWR VGND sky130_ef_sc_hd__decap_12
X_4315_ _1735_ _0063_ _0062_ VGND VGND VPWR VPWR _0085_ sky130_fd_sc_hd__o21a_1
XFILLER_113_141 VPWR VGND VPWR VGND sky130_ef_sc_hd__decap_12
XFILLER_87_537 VGND VGND VPWR VPWR sky130_fd_sc_hd__fill_1
X_5295_ _0973_ net115 _1078_ VGND VGND VPWR VPWR _1079_ sky130_fd_sc_hd__or3_2
XFILLER_101_347 VPWR VGND VPWR VGND sky130_ef_sc_hd__decap_12
X_4246_ net131 _0009_ VGND VGND VPWR VPWR _0022_ sky130_fd_sc_hd__nand2_1
XFILLER_19_27 VPWR VGND VPWR VGND sky130_ef_sc_hd__decap_12
X_4177_ _0885_ net255 VGND VGND VPWR VPWR _3357_ sky130_fd_sc_hd__nor2_1
XFILLER_27_125 VPWR VGND VPWR VGND sky130_ef_sc_hd__decap_12
XFILLER_28_637 VGND VGND VPWR VPWR sky130_fd_sc_hd__decap_6
XFILLER_82_253 VPWR VGND VPWR VGND sky130_ef_sc_hd__decap_12
XTAP_TAPCELL_ROW_2_279 VGND VPWR sky130_fd_sc_hd__tapvpwrvgnd_1
XFILLER_35_15 VPWR VGND VPWR VGND sky130_ef_sc_hd__decap_12
XFILLER_36_681 VGND VGND VPWR VPWR sky130_fd_sc_hd__decap_8
XFILLER_43_629 VPWR VGND VPWR VGND sky130_ef_sc_hd__decap_12
XFILLER_70_459 VPWR VGND VPWR VGND sky130_ef_sc_hd__decap_12
X_6818_ _2734_ _2740_ VGND VGND VPWR VPWR _2741_ sky130_fd_sc_hd__xnor2_1
XFILLER_51_673 VPWR VGND VPWR VGND sky130_ef_sc_hd__decap_12
XTAP_TAPCELL_ROW_98_1431 VGND VPWR sky130_fd_sc_hd__tapvpwrvgnd_1
XFILLER_11_559 VGND VGND VPWR VPWR sky130_fd_sc_hd__fill_1
X_6749_ _alu_i0.Datapath_i.reg_0.reg_out1\[30\] net149 VGND VGND VPWR VPWR _2666_
+ sky130_fd_sc_hd__and2_1
XFILLER_105_653 VPWR VGND VPWR VGND sky130_ef_sc_hd__decap_12
XFILLER_104_141 VPWR VGND VPWR VGND sky130_ef_sc_hd__decap_12
XFILLER_93_529 VPWR VGND VPWR VGND sky130_ef_sc_hd__decap_12
XFILLER_58_250 VGND VGND VPWR VPWR sky130_fd_sc_hd__fill_2
XTAP_TAPCELL_ROW_57_930 VGND VPWR sky130_fd_sc_hd__tapvpwrvgnd_1
XFILLER_46_401 VPWR VGND VPWR VGND sky130_ef_sc_hd__decap_12
XTAP_TAPCELL_ROW_57_941 VGND VPWR sky130_fd_sc_hd__tapvpwrvgnd_1
XFILLER_18_136 VGND VGND VPWR VPWR sky130_fd_sc_hd__decap_4
XFILLER_61_437 VGND VGND VPWR VPWR sky130_fd_sc_hd__decap_8
XFILLER_25_81 VGND VGND VPWR VPWR sky130_fd_sc_hd__decap_6
XFILLER_41_194 VGND VGND VPWR VPWR sky130_fd_sc_hd__decap_4
XFILLER_10_581 VGND VGND VPWR VPWR sky130_fd_sc_hd__decap_6
XFILLER_115_417 VPWR VGND VPWR VGND sky130_ef_sc_hd__decap_12
XFILLER_108_491 VGND VGND VPWR VPWR sky130_fd_sc_hd__fill_2
XTAP_TAPCELL_ROW_71_1103 VGND VPWR sky130_fd_sc_hd__tapvpwrvgnd_1
X_5080_ _0831_ _0843_ VGND VGND VPWR VPWR _0845_ sky130_fd_sc_hd__xnor2_1
X_4100_ net438 net265 VGND VGND VPWR VPWR _3283_ sky130_fd_sc_hd__nand2_1
XFILLER_2_41 VPWR VGND VPWR VGND sky130_ef_sc_hd__decap_12
X_4031_ net132 _3200_ _3217_ _1539_ VGND VGND VPWR VPWR _3218_ sky130_fd_sc_hd__a211o_1
XFILLER_110_177 VPWR VGND VPWR VGND sky130_ef_sc_hd__decap_12
XFILLER_77_592 VPWR VGND VPWR VGND sky130_ef_sc_hd__decap_12
XFILLER_2_85 VGND VGND VPWR VPWR sky130_fd_sc_hd__decap_6
XFILLER_37_401 VGND VGND VPWR VPWR sky130_fd_sc_hd__fill_2
XFILLER_37_423 VPWR VGND VPWR VGND sky130_ef_sc_hd__decap_12
XFILLER_92_573 VPWR VGND VPWR VGND sky130_ef_sc_hd__decap_12
XFILLER_92_562 VGND VGND VPWR VPWR sky130_fd_sc_hd__fill_1
XTAP_TAPCELL_ROW_69_1076 VGND VPWR sky130_fd_sc_hd__tapvpwrvgnd_1
XFILLER_52_415 VGND VGND VPWR VPWR sky130_fd_sc_hd__decap_4
XFILLER_18_681 VGND VGND VPWR VPWR sky130_fd_sc_hd__decap_4
XFILLER_25_629 VPWR VGND VPWR VGND sky130_ef_sc_hd__decap_12
X_5982_ _1820_ _1827_ _1828_ VGND VGND VPWR VPWR _1829_ sky130_fd_sc_hd__nand3_2
X_4933_ _0574_ _0576_ _0690_ _0691_ VGND VGND VPWR VPWR _0692_ sky130_fd_sc_hd__a211oi_2
XTAP_TAPCELL_ROW_82_1232 VGND VPWR sky130_fd_sc_hd__tapvpwrvgnd_1
XFILLER_33_673 VPWR VGND VPWR VGND sky130_ef_sc_hd__decap_12
XTAP_TAPCELL_ROW_35_668 VGND VPWR sky130_fd_sc_hd__tapvpwrvgnd_1
X_4864_ _0622_ VGND VGND VPWR VPWR _0623_ sky130_fd_sc_hd__inv_2
XANTENNA_13 reset VGND VGND VPWR VPWR sky130_fd_sc_hd__diode_2
XFILLER_20_312 VPWR VGND VPWR VGND sky130_ef_sc_hd__decap_12
XFILLER_32_161 VPWR VGND VPWR VGND sky130_ef_sc_hd__decap_12
XANTENNA_35 net418 VGND VGND VPWR VPWR sky130_fd_sc_hd__diode_2
X_4795_ _0552_ _0553_ _0554_ VGND VGND VPWR VPWR _0555_ sky130_fd_sc_hd__and3_1
X_3815_ _2981_ _3005_ VGND VGND VPWR VPWR _3011_ sky130_fd_sc_hd__nand2_1
X_6603_ _2502_ _2503_ _2500_ VGND VGND VPWR VPWR _2505_ sky130_fd_sc_hd__a21oi_1
XFILLER_20_356 VGND VGND VPWR VPWR sky130_fd_sc_hd__fill_1
XANTENNA_24 net320 VGND VGND VPWR VPWR sky130_fd_sc_hd__diode_2
X_3746_ _2942_ _2944_ VGND VGND VPWR VPWR _2945_ sky130_fd_sc_hd__nor2_2
X_6534_ _2430_ VGND VGND VPWR VPWR _2431_ sky130_fd_sc_hd__inv_2
X_6465_ _2342_ _2354_ VGND VGND VPWR VPWR _2355_ sky130_fd_sc_hd__and2_1
XFILLER_21_39 VPWR VGND VPWR VGND sky130_ef_sc_hd__decap_12
X_5416_ _0700_ _0701_ _0993_ _0995_ _1209_ VGND VGND VPWR VPWR _1211_ sky130_fd_sc_hd__o311a_1
X_3677_ net144 _2869_ _2878_ net124 net137 VGND VGND VPWR VPWR _2879_ sky130_fd_sc_hd__a221o_1
X_6396_ _2172_ _2279_ VGND VGND VPWR VPWR _2280_ sky130_fd_sc_hd__or2_1
XFILLER_102_601 VPWR VGND VPWR VGND sky130_ef_sc_hd__decap_12
XTAP_TAPCELL_ROW_93_1372 VGND VPWR sky130_fd_sc_hd__tapvpwrvgnd_1
X_5347_ _1025_ _1028_ _1133_ _1134_ VGND VGND VPWR VPWR _1136_ sky130_fd_sc_hd__o211ai_4
XTAP_TAPCELL_ROW_7_338 VGND VPWR sky130_fd_sc_hd__tapvpwrvgnd_1
XFILLER_102_645 VPWR VGND VPWR VGND sky130_ef_sc_hd__decap_12
X_5278_ _1060_ VGND VGND VPWR VPWR _1061_ sky130_fd_sc_hd__inv_2
XFILLER_102_689 VGND VGND VPWR VPWR sky130_fd_sc_hd__decap_3
X_4229_ net157 _3241_ _0005_ net120 VGND VGND VPWR VPWR _0006_ sky130_fd_sc_hd__o211a_1
XFILLER_75_529 VGND VGND VPWR VPWR sky130_fd_sc_hd__decap_8
XFILLER_28_445 VPWR VGND VPWR VGND sky130_ef_sc_hd__decap_12
XFILLER_83_584 VPWR VGND VPWR VGND sky130_ef_sc_hd__decap_12
XTAP_TAPCELL_ROW_54_900 VGND VPWR sky130_fd_sc_hd__tapvpwrvgnd_1
XFILLER_43_415 VPWR VGND VPWR VGND sky130_ef_sc_hd__decap_12
XFILLER_102_53 VPWR VGND VPWR VGND sky130_ef_sc_hd__decap_12
XFILLER_70_278 VGND VGND VPWR VPWR sky130_fd_sc_hd__fill_1
XFILLER_30_109 VGND VGND VPWR VPWR sky130_fd_sc_hd__decap_8
XFILLER_11_356 VGND VGND VPWR VPWR sky130_fd_sc_hd__fill_1
XFILLER_11_345 VGND VGND VPWR VPWR sky130_fd_sc_hd__decap_6
XFILLER_23_194 VPWR VGND VPWR VGND sky130_ef_sc_hd__decap_12
XFILLER_11_94 VPWR VGND VPWR VGND sky130_ef_sc_hd__decap_12
XFILLER_93_337 VPWR VGND VPWR VGND sky130_ef_sc_hd__decap_12
XFILLER_93_326 VGND VGND VPWR VPWR sky130_fd_sc_hd__decap_8
Xfanout391 net392 VGND VGND VPWR VPWR net391 sky130_fd_sc_hd__buf_2
Xfanout380 net381 VGND VGND VPWR VPWR net380 sky130_fd_sc_hd__clkbuf_2
XFILLER_66_529 VGND VGND VPWR VPWR sky130_fd_sc_hd__decap_3
XTAP_TAPCELL_ROW_105_1508 VGND VPWR sky130_fd_sc_hd__tapvpwrvgnd_1
XFILLER_34_404 VGND VGND VPWR VPWR sky130_fd_sc_hd__fill_1
XFILLER_61_245 VPWR VGND VPWR VGND sky130_ef_sc_hd__decap_12
XFILLER_15_673 VPWR VGND VPWR VGND sky130_ef_sc_hd__decap_12
XFILLER_30_621 VPWR VGND VPWR VGND sky130_ef_sc_hd__decap_12
XTAP_TAPCELL_ROW_32_638 VGND VPWR sky130_fd_sc_hd__tapvpwrvgnd_1
XTAP_TAPCELL_ROW_60_969 VGND VPWR sky130_fd_sc_hd__tapvpwrvgnd_1
X_4580_ _alu_i0.Datapath_i.reg_0.reg_out1\[10\] _0343_ net146 VGND VGND VPWR VPWR
+ net78 sky130_fd_sc_hd__mux2_1
X_3600_ net145 _2717_ _2783_ _2804_ VGND VGND VPWR VPWR _alu_i0.Datapath_i.fu_alu_33673_33851.out1\[2\]
+ sky130_fd_sc_hd__a211o_1
Xinput11 a[19] VGND VGND VPWR VPWR net11 sky130_fd_sc_hd__clkbuf_2
Xinput22 a[29] VGND VGND VPWR VPWR net22 sky130_fd_sc_hd__buf_2
Xinput44 b[1] VGND VGND VPWR VPWR net44 sky130_fd_sc_hd__buf_2
Xinput33 b[0] VGND VGND VPWR VPWR net33 sky130_fd_sc_hd__buf_1
Xinput55 b[2] VGND VGND VPWR VPWR net55 sky130_fd_sc_hd__clkbuf_2
X_3531_ _2062_ _2117_ net250 VGND VGND VPWR VPWR _2139_ sky130_fd_sc_hd__mux2_1
XTAP_TAPCELL_ROW_12_395 VGND VPWR sky130_fd_sc_hd__tapvpwrvgnd_1
XTAP_TAPCELL_ROW_116_1648 VGND VPWR sky130_fd_sc_hd__tapvpwrvgnd_1
Xinput66 opcode[0] VGND VGND VPWR VPWR net66 sky130_fd_sc_hd__buf_1
XTAP_TAPCELL_ROW_116_1659 VGND VPWR sky130_fd_sc_hd__tapvpwrvgnd_1
XFILLER_115_225 VGND VGND VPWR VPWR sky130_fd_sc_hd__decap_4
X_3462_ _1353_ _1375_ net282 VGND VGND VPWR VPWR _1386_ sky130_fd_sc_hd__mux2_1
X_6250_ net283 net19 _2120_ VGND VGND VPWR VPWR _2121_ sky130_fd_sc_hd__nand3_1
X_5201_ _0934_ _0935_ _0976_ VGND VGND VPWR VPWR _0977_ sky130_fd_sc_hd__nand3_2
X_6181_ _2043_ _2044_ VGND VGND VPWR VPWR _2045_ sky130_fd_sc_hd__nor2_1
X_5132_ _0899_ _0900_ VGND VGND VPWR VPWR _0901_ sky130_fd_sc_hd__nor2_1
XFILLER_111_453 VPWR VGND VPWR VGND sky130_ef_sc_hd__decap_12
XFILLER_97_665 VGND VGND VPWR VPWR sky130_fd_sc_hd__decap_6
XFILLER_69_367 VPWR VGND VPWR VGND sky130_ef_sc_hd__decap_12
XFILLER_96_197 VGND VGND VPWR VPWR sky130_fd_sc_hd__decap_8
XFILLER_84_326 VPWR VGND VPWR VGND sky130_ef_sc_hd__decap_12
X_5063_ _0824_ _0825_ VGND VGND VPWR VPWR _0826_ sky130_fd_sc_hd__nand2_1
X_4014_ net464 net298 _3183_ _3184_ VGND VGND VPWR VPWR _3201_ sky130_fd_sc_hd__a31o_1
XFILLER_92_370 VGND VGND VPWR VPWR sky130_fd_sc_hd__fill_1
XFILLER_80_543 VPWR VGND VPWR VGND sky130_ef_sc_hd__decap_12
XFILLER_80_576 VGND VGND VPWR VPWR sky130_fd_sc_hd__fill_2
X_5965_ net283 net439 VGND VGND VPWR VPWR _1810_ sky130_fd_sc_hd__nand2_1
X_4916_ _0672_ _0673_ _0586_ _0589_ VGND VGND VPWR VPWR _0675_ sky130_fd_sc_hd__o211a_1
X_5896_ _1732_ _1733_ VGND VGND VPWR VPWR _1734_ sky130_fd_sc_hd__or2_1
XFILLER_52_289 VPWR VGND VPWR VGND sky130_ef_sc_hd__decap_12
X_4847_ _0605_ _0606_ _0525_ VGND VGND VPWR VPWR _0607_ sky130_fd_sc_hd__a21oi_1
XFILLER_21_665 VGND VGND VPWR VPWR sky130_fd_sc_hd__decap_6
XFILLER_32_27 VGND VGND VPWR VPWR sky130_fd_sc_hd__fill_1
XFILLER_20_175 VPWR VGND VPWR VGND sky130_ef_sc_hd__decap_12
X_4778_ _0535_ _0536_ _0464_ _0467_ VGND VGND VPWR VPWR _0539_ sky130_fd_sc_hd__o211a_1
XFILLER_20_197 VPWR VGND VPWR VGND sky130_ef_sc_hd__decap_12
X_3729_ net127 _2925_ _2926_ _2928_ VGND VGND VPWR VPWR _2929_ sky130_fd_sc_hd__a31o_1
X_6517_ _2403_ _2411_ VGND VGND VPWR VPWR _2413_ sky130_fd_sc_hd__or2_1
XFILLER_106_7 VPWR VGND VPWR VGND sky130_ef_sc_hd__decap_12
X_6448_ net451 net419 net253 net53 VGND VGND VPWR VPWR _2337_ sky130_fd_sc_hd__and4_1
X_6379_ _2222_ _2223_ _2258_ _2260_ VGND VGND VPWR VPWR _2262_ sky130_fd_sc_hd__a2bb2oi_1
XFILLER_88_643 VGND VGND VPWR VPWR sky130_fd_sc_hd__fill_1
XFILLER_75_315 VGND VGND VPWR VPWR sky130_fd_sc_hd__decap_8
XFILLER_56_584 VGND VGND VPWR VPWR sky130_fd_sc_hd__decap_4
XFILLER_28_253 VGND VGND VPWR VPWR sky130_fd_sc_hd__decap_8
XFILLER_28_264 VPWR VGND VPWR VGND sky130_ef_sc_hd__decap_12
XFILLER_73_34 VPWR VGND VPWR VGND sky130_ef_sc_hd__decap_12
XFILLER_43_223 VGND VGND VPWR VPWR sky130_fd_sc_hd__fill_1
XTAP_TAPCELL_ROW_100_1449 VGND VPWR sky130_fd_sc_hd__tapvpwrvgnd_1
XFILLER_12_643 VGND VGND VPWR VPWR sky130_fd_sc_hd__fill_1
XFILLER_8_625 VPWR VGND VPWR VGND sky130_ef_sc_hd__decap_12
XFILLER_8_669 VPWR VGND VPWR VGND sky130_ef_sc_hd__decap_12
XFILLER_22_82 VGND VGND VPWR VPWR sky130_fd_sc_hd__fill_2
XFILLER_98_53 VGND VGND VPWR VPWR sky130_fd_sc_hd__decap_3
XTAP_TAPCELL_ROW_111_1578 VGND VPWR sky130_fd_sc_hd__tapvpwrvgnd_1
XFILLER_79_665 VGND VGND VPWR VPWR sky130_fd_sc_hd__decap_6
XFILLER_78_153 VPWR VGND VPWR VGND sky130_ef_sc_hd__decap_12
XTAP_TAPCELL_ROW_111_1589 VGND VPWR sky130_fd_sc_hd__tapvpwrvgnd_1
XFILLER_94_613 VPWR VGND VPWR VGND sky130_ef_sc_hd__decap_12
XFILLER_66_326 VGND VGND VPWR VPWR sky130_fd_sc_hd__fill_1
XFILLER_94_657 VPWR VGND VPWR VGND sky130_ef_sc_hd__decap_12
XFILLER_78_197 VPWR VGND VPWR VGND sky130_ef_sc_hd__decap_12
XFILLER_47_540 VPWR VGND VPWR VGND sky130_ef_sc_hd__decap_12
XFILLER_93_167 VGND VGND VPWR VPWR sky130_fd_sc_hd__fill_1
XFILLER_47_573 VGND VGND VPWR VPWR sky130_fd_sc_hd__decap_6
XFILLER_62_543 VGND VGND VPWR VPWR sky130_fd_sc_hd__decap_3
XFILLER_62_510 VPWR VGND VPWR VGND sky130_ef_sc_hd__decap_12
XTAP_TAPCELL_ROW_66_1046 VGND VPWR sky130_fd_sc_hd__tapvpwrvgnd_1
XFILLER_62_565 VGND VGND VPWR VPWR sky130_fd_sc_hd__decap_8
XTAP_TAPCELL_ROW_17_454 VGND VPWR sky130_fd_sc_hd__tapvpwrvgnd_1
XFILLER_97_3 VPWR VGND VPWR VGND sky130_ef_sc_hd__decap_12
X_5750_ _1442_ _1444_ _1574_ _1575_ VGND VGND VPWR VPWR _1576_ sky130_fd_sc_hd__a211oi_1
XFILLER_34_289 VPWR VGND VPWR VGND sky130_ef_sc_hd__decap_12
XTAP_TAPCELL_ROW_45_796 VGND VPWR sky130_fd_sc_hd__tapvpwrvgnd_1
X_4701_ _0393_ _0397_ _0461_ _0462_ VGND VGND VPWR VPWR _0463_ sky130_fd_sc_hd__a211oi_1
X_5681_ _1416_ _1418_ VGND VGND VPWR VPWR _1500_ sky130_fd_sc_hd__nand2_1
X_4632_ _0393_ _0394_ _0325_ VGND VGND VPWR VPWR _0395_ sky130_fd_sc_hd__a21boi_1
XFILLER_116_501 VGND VGND VPWR VPWR sky130_fd_sc_hd__decap_3
X_4563_ _0294_ _0325_ _0326_ VGND VGND VPWR VPWR _0327_ sky130_fd_sc_hd__and3_1
X_4494_ _0255_ _0258_ VGND VGND VPWR VPWR _0259_ sky130_fd_sc_hd__xnor2_1
X_3514_ _0776_ net66 _1102_ VGND VGND VPWR VPWR _1953_ sky130_fd_sc_hd__and3_2
X_6302_ net419 net254 VGND VGND VPWR VPWR _2177_ sky130_fd_sc_hd__nand2_1
XFILLER_7_691 VGND VGND VPWR VPWR sky130_fd_sc_hd__fill_1
XFILLER_116_589 VGND VGND VPWR VPWR sky130_fd_sc_hd__decap_4
XTAP_TAPCELL_ROW_77_1175 VGND VPWR sky130_fd_sc_hd__tapvpwrvgnd_1
X_3445_ _1048_ net67 net179 VGND VGND VPWR VPWR _1201_ sky130_fd_sc_hd__or3b_1
X_6233_ _2099_ _2100_ _2085_ VGND VGND VPWR VPWR _2102_ sky130_fd_sc_hd__o21a_1
XTAP_TAPCELL_ROW_90_1331 VGND VPWR sky130_fd_sc_hd__tapvpwrvgnd_1
X_6164_ _2024_ _2025_ VGND VGND VPWR VPWR _2026_ sky130_fd_sc_hd__xnor2_1
XFILLER_97_473 VGND VGND VPWR VPWR sky130_fd_sc_hd__decap_4
X_5115_ _0880_ _0881_ _0744_ _0746_ VGND VGND VPWR VPWR _0883_ sky130_fd_sc_hd__o211a_1
X_6095_ _1949_ _1950_ VGND VGND VPWR VPWR _1951_ sky130_fd_sc_hd__nor2_1
XFILLER_84_134 VGND VGND VPWR VPWR sky130_fd_sc_hd__decap_6
X_5046_ _0803_ _0804_ _0805_ VGND VGND VPWR VPWR _0807_ sky130_fd_sc_hd__a21o_1
XFILLER_57_337 VGND VGND VPWR VPWR sky130_fd_sc_hd__decap_8
XFILLER_27_27 VPWR VGND VPWR VGND sky130_ef_sc_hd__decap_12
XFILLER_38_562 VGND VGND VPWR VPWR sky130_fd_sc_hd__decap_4
XFILLER_25_234 VGND VGND VPWR VPWR sky130_fd_sc_hd__decap_6
X_5948_ _1791_ VGND VGND VPWR VPWR _1792_ sky130_fd_sc_hd__inv_2
X_5879_ _1576_ _1578_ VGND VGND VPWR VPWR _1717_ sky130_fd_sc_hd__nor2_1
XFILLER_5_617 VPWR VGND VPWR VGND sky130_ef_sc_hd__decap_12
XFILLER_108_41 VPWR VGND VPWR VGND sky130_ef_sc_hd__decap_12
XFILLER_108_85 VPWR VGND VPWR VGND sky130_ef_sc_hd__decap_12
XFILLER_108_74 VGND VGND VPWR VPWR sky130_fd_sc_hd__decap_8
XFILLER_76_657 VPWR VGND VPWR VGND sky130_ef_sc_hd__decap_12
XFILLER_91_605 VGND VGND VPWR VPWR sky130_fd_sc_hd__decap_8
XFILLER_90_104 VGND VGND VPWR VPWR sky130_fd_sc_hd__fill_1
XFILLER_63_318 VGND VGND VPWR VPWR sky130_fd_sc_hd__decap_4
XFILLER_63_307 VGND VGND VPWR VPWR sky130_fd_sc_hd__fill_1
XFILLER_29_573 VPWR VGND VPWR VGND sky130_ef_sc_hd__decap_12
XFILLER_63_329 VGND VGND VPWR VPWR sky130_fd_sc_hd__decap_6
XFILLER_44_565 VGND VGND VPWR VPWR sky130_fd_sc_hd__fill_1
XFILLER_16_289 VPWR VGND VPWR VGND sky130_ef_sc_hd__decap_12
XFILLER_44_587 VGND VGND VPWR VPWR sky130_fd_sc_hd__fill_1
XTAP_TAPCELL_ROW_14_424 VGND VPWR sky130_fd_sc_hd__tapvpwrvgnd_1
XFILLER_31_237 VGND VGND VPWR VPWR sky130_fd_sc_hd__decap_8
XTAP_TAPCELL_ROW_42_755 VGND VPWR sky130_fd_sc_hd__tapvpwrvgnd_1
XFILLER_12_484 VPWR VGND VPWR VGND sky130_ef_sc_hd__decap_12
XFILLER_8_433 VPWR VGND VPWR VGND sky130_ef_sc_hd__decap_12
XFILLER_33_81 VPWR VGND VPWR VGND sky130_ef_sc_hd__decap_12
XFILLER_8_477 VPWR VGND VPWR VGND sky130_ef_sc_hd__decap_12
XTAP_TAPCELL_ROW_113_1607 VGND VPWR sky130_fd_sc_hd__tapvpwrvgnd_1
XFILLER_113_559 VGND VGND VPWR VPWR sky130_fd_sc_hd__fill_1
XFILLER_79_440 VGND VGND VPWR VPWR sky130_fd_sc_hd__decap_8
XFILLER_100_209 VGND VGND VPWR VPWR sky130_fd_sc_hd__decap_4
XFILLER_94_421 VGND VGND VPWR VPWR sky130_fd_sc_hd__decap_8
XFILLER_67_646 VPWR VGND VPWR VGND sky130_ef_sc_hd__decap_12
XFILLER_12_3 VPWR VGND VPWR VGND sky130_ef_sc_hd__decap_12
XFILLER_35_532 VGND VGND VPWR VPWR sky130_fd_sc_hd__decap_6
XFILLER_81_148 VGND VGND VPWR VPWR sky130_fd_sc_hd__fill_1
X_6851_ _2587_ _2590_ VGND VGND VPWR VPWR _2777_ sky130_fd_sc_hd__nor2_1
X_5802_ net368 net360 net315 net307 VGND VGND VPWR VPWR _1632_ sky130_fd_sc_hd__nand4_1
XFILLER_50_513 VGND VGND VPWR VPWR sky130_fd_sc_hd__fill_1
XFILLER_22_237 VGND VGND VPWR VPWR sky130_fd_sc_hd__decap_8
X_6782_ _2681_ _2700_ VGND VGND VPWR VPWR _2701_ sky130_fd_sc_hd__xnor2_1
X_3994_ net460 net293 VGND VGND VPWR VPWR _3182_ sky130_fd_sc_hd__nor2_1
XFILLER_50_568 VGND VGND VPWR VPWR sky130_fd_sc_hd__fill_2
X_5733_ _1361_ _1365_ _1555_ _1556_ VGND VGND VPWR VPWR _1557_ sky130_fd_sc_hd__a211oi_4
XTAP_TAPCELL_ROW_79_1204 VGND VPWR sky130_fd_sc_hd__tapvpwrvgnd_1
X_5664_ _1478_ _1479_ _1461_ VGND VGND VPWR VPWR _1481_ sky130_fd_sc_hd__o21ai_1
X_4615_ _0375_ _0376_ _0372_ VGND VGND VPWR VPWR _0378_ sky130_fd_sc_hd__a21o_1
X_5595_ _1404_ _1405_ _3003_ VGND VGND VPWR VPWR _1406_ sky130_fd_sc_hd__a21o_1
X_4546_ net357 net431 _0308_ _0309_ VGND VGND VPWR VPWR _0310_ sky130_fd_sc_hd__a22o_1
XFILLER_116_375 VGND VGND VPWR VPWR sky130_fd_sc_hd__fill_1
XFILLER_104_515 VPWR VGND VPWR VGND sky130_ef_sc_hd__decap_12
X_4477_ _0240_ _0241_ _0239_ VGND VGND VPWR VPWR _0242_ sky130_fd_sc_hd__a21o_1
X_3428_ net72 net71 net73 net70 VGND VGND VPWR VPWR _1015_ sky130_fd_sc_hd__or4_1
X_6216_ _2072_ _2081_ VGND VGND VPWR VPWR _2083_ sky130_fd_sc_hd__nor2_1
XFILLER_57_101 VGND VGND VPWR VPWR sky130_fd_sc_hd__decap_8
XFILLER_38_15 VPWR VGND VPWR VGND sky130_ef_sc_hd__decap_12
X_6147_ _2005_ _2006_ _1814_ _1817_ VGND VGND VPWR VPWR _2009_ sky130_fd_sc_hd__a211o_1
XFILLER_112_581 VGND VGND VPWR VPWR sky130_fd_sc_hd__decap_6
XFILLER_58_657 VPWR VGND VPWR VGND sky130_ef_sc_hd__decap_12
XFILLER_57_156 VGND VGND VPWR VPWR sky130_fd_sc_hd__fill_1
X_6078_ _1929_ _1930_ _1932_ VGND VGND VPWR VPWR _1933_ sky130_fd_sc_hd__and3_1
X_5029_ _0784_ _0785_ _0786_ VGND VGND VPWR VPWR _0790_ sky130_fd_sc_hd__a21oi_1
XFILLER_54_14 VPWR VGND VPWR VGND sky130_ef_sc_hd__decap_12
XFILLER_26_510 VGND VGND VPWR VPWR sky130_fd_sc_hd__decap_8
XFILLER_81_671 VGND VGND VPWR VPWR sky130_fd_sc_hd__fill_1
XFILLER_13_204 VGND VGND VPWR VPWR sky130_fd_sc_hd__fill_2
XFILLER_26_587 VGND VGND VPWR VPWR sky130_fd_sc_hd__fill_1
XFILLER_41_513 VPWR VGND VPWR VGND sky130_ef_sc_hd__decap_12
XFILLER_53_384 VGND VGND VPWR VPWR sky130_fd_sc_hd__decap_8
XFILLER_110_53 VPWR VGND VPWR VGND sky130_ef_sc_hd__decap_12
XFILLER_13_237 VGND VGND VPWR VPWR sky130_fd_sc_hd__decap_6
XFILLER_21_281 VGND VGND VPWR VPWR sky130_fd_sc_hd__decap_3
XFILLER_5_447 VGND VGND VPWR VPWR sky130_fd_sc_hd__fill_1
XFILLER_79_55 VGND VGND VPWR VPWR sky130_fd_sc_hd__fill_1
XFILLER_1_653 VPWR VGND VPWR VGND sky130_ef_sc_hd__decap_12
XFILLER_76_421 VPWR VGND VPWR VGND sky130_ef_sc_hd__decap_12
XFILLER_0_185 VGND VGND VPWR VPWR sky130_fd_sc_hd__fill_2
XFILLER_48_123 VGND VGND VPWR VPWR sky130_fd_sc_hd__fill_1
XFILLER_64_627 VPWR VGND VPWR VGND sky130_ef_sc_hd__decap_12
XTAP_TAPCELL_ROW_47_814 VGND VPWR sky130_fd_sc_hd__tapvpwrvgnd_1
XFILLER_63_137 VGND VGND VPWR VPWR sky130_fd_sc_hd__fill_1
XFILLER_48_178 VGND VGND VPWR VPWR sky130_fd_sc_hd__fill_2
XFILLER_63_159 VGND VGND VPWR VPWR sky130_fd_sc_hd__decap_8
XFILLER_17_532 VGND VGND VPWR VPWR sky130_fd_sc_hd__fill_2
XTAP_TAPCELL_ROW_63_1005 VGND VPWR sky130_fd_sc_hd__tapvpwrvgnd_1
XTAP_TAPCELL_ROW_27_571 VGND VPWR sky130_fd_sc_hd__tapvpwrvgnd_1
XFILLER_32_524 VGND VGND VPWR VPWR sky130_fd_sc_hd__fill_2
XFILLER_44_80 VGND VGND VPWR VPWR sky130_fd_sc_hd__decap_4
XFILLER_12_281 VGND VGND VPWR VPWR sky130_fd_sc_hd__decap_8
X_4400_ _0164_ _0165_ _0166_ VGND VGND VPWR VPWR _0167_ sky130_fd_sc_hd__and3_1
X_5380_ net421 net303 _1041_ _1040_ VGND VGND VPWR VPWR _1172_ sky130_fd_sc_hd__a31o_1
X_4331_ _0097_ _0098_ _0099_ VGND VGND VPWR VPWR _0100_ sky130_fd_sc_hd__and3_1
XTAP_TAPCELL_ROW_74_1145 VGND VPWR sky130_fd_sc_hd__tapvpwrvgnd_1
XTAP_TAPCELL_ROW_74_1134 VGND VPWR sky130_fd_sc_hd__tapvpwrvgnd_1
Xfanout209 net61 VGND VGND VPWR VPWR net209 sky130_fd_sc_hd__clkbuf_2
XFILLER_113_334 VGND VGND VPWR VPWR sky130_fd_sc_hd__fill_2
X_4262_ net138 _0030_ _0035_ _0036_ VGND VGND VPWR VPWR _0037_ sky130_fd_sc_hd__o2bb2a_1
X_6001_ _1656_ net110 _1846_ _1847_ VGND VGND VPWR VPWR _1849_ sky130_fd_sc_hd__o211ai_1
XFILLER_79_281 VPWR VGND VPWR VGND sky130_ef_sc_hd__decap_12
X_4193_ _3331_ _3339_ _3350_ _3352_ VGND VGND VPWR VPWR _3372_ sky130_fd_sc_hd__a31o_1
XFILLER_67_498 VGND VGND VPWR VPWR sky130_fd_sc_hd__decap_6
XFILLER_27_329 VGND VGND VPWR VPWR sky130_fd_sc_hd__decap_6
XFILLER_70_608 VGND VGND VPWR VPWR sky130_fd_sc_hd__decap_4
X_6903_ net182 _alu_i0.Datapath_i.fu_alu_33673_33851.out1\[29\] VGND VGND VPWR VPWR
+ _alu_i0.Datapath_i.reg_0.reg_out1\[29\] sky130_fd_sc_hd__dfxtp_1
XTAP_TAPCELL_ROW_85_1274 VGND VPWR sky130_fd_sc_hd__tapvpwrvgnd_1
XFILLER_23_513 VGND VGND VPWR VPWR sky130_fd_sc_hd__fill_1
XFILLER_23_535 VPWR VGND VPWR VGND sky130_ef_sc_hd__decap_12
X_6834_ net460 net336 _2562_ _2563_ net329 VGND VGND VPWR VPWR _2758_ sky130_fd_sc_hd__a32o_1
X_6765_ net245 net427 _2604_ _2603_ VGND VGND VPWR VPWR _2682_ sky130_fd_sc_hd__a31o_1
XFILLER_50_365 VGND VGND VPWR VPWR sky130_fd_sc_hd__decap_3
X_3977_ _3146_ _3162_ _3164_ _3165_ net126 VGND VGND VPWR VPWR _3166_ sky130_fd_sc_hd__o311a_1
X_5716_ _1345_ _1346_ _1344_ VGND VGND VPWR VPWR _1538_ sky130_fd_sc_hd__a21oi_2
XFILLER_109_629 VPWR VGND VPWR VGND sky130_ef_sc_hd__decap_12
X_6696_ net245 net428 _2430_ _2432_ VGND VGND VPWR VPWR _2607_ sky130_fd_sc_hd__a31o_1
XFILLER_40_27 VGND VGND VPWR VPWR sky130_fd_sc_hd__fill_1
XFILLER_108_139 VGND VGND VPWR VPWR sky130_fd_sc_hd__fill_1
X_5647_ net453 net420 net272 net269 VGND VGND VPWR VPWR _1463_ sky130_fd_sc_hd__and4_1
XFILLER_40_49 VGND VGND VPWR VPWR sky130_fd_sc_hd__fill_2
X_5578_ net411 net403 net299 net294 VGND VGND VPWR VPWR _1388_ sky130_fd_sc_hd__and4_1
X_4529_ _0291_ _0292_ VGND VGND VPWR VPWR _0293_ sky130_fd_sc_hd__and2b_1
XFILLER_104_389 VPWR VGND VPWR VGND sky130_ef_sc_hd__decap_12
XFILLER_58_421 VPWR VGND VPWR VGND sky130_ef_sc_hd__decap_12
XFILLER_46_605 VGND VGND VPWR VPWR sky130_fd_sc_hd__fill_1
XFILLER_73_435 VPWR VGND VPWR VGND sky130_ef_sc_hd__decap_12
XFILLER_65_57 VPWR VGND VPWR VGND sky130_ef_sc_hd__decap_12
XFILLER_45_137 VGND VGND VPWR VPWR sky130_fd_sc_hd__decap_6
XFILLER_45_159 VGND VGND VPWR VPWR sky130_fd_sc_hd__decap_8
XFILLER_73_479 VGND VGND VPWR VPWR sky130_fd_sc_hd__fill_1
XFILLER_81_45 VGND VGND VPWR VPWR sky130_fd_sc_hd__fill_1
XFILLER_14_557 VPWR VGND VPWR VGND sky130_ef_sc_hd__decap_12
XTAP_TAPCELL_ROW_24_541 VGND VPWR sky130_fd_sc_hd__tapvpwrvgnd_1
XFILLER_41_376 VPWR VGND VPWR VGND sky130_ef_sc_hd__decap_12
XTAP_TAPCELL_ROW_52_872 VGND VPWR sky130_fd_sc_hd__tapvpwrvgnd_1
XFILLER_14_83 VGND VGND VPWR VPWR sky130_fd_sc_hd__fill_1
XFILLER_114_109 VPWR VGND VPWR VGND sky130_ef_sc_hd__decap_12
XFILLER_68_229 VPWR VGND VPWR VGND sky130_ef_sc_hd__decap_12
XFILLER_76_262 VGND VGND VPWR VPWR sky130_fd_sc_hd__decap_6
XFILLER_64_402 VGND VGND VPWR VPWR sky130_fd_sc_hd__decap_6
Xinput9 a[17] VGND VGND VPWR VPWR net9 sky130_fd_sc_hd__buf_1
XFILLER_91_221 VGND VGND VPWR VPWR sky130_fd_sc_hd__decap_3
XFILLER_45_671 VGND VGND VPWR VPWR sky130_fd_sc_hd__fill_1
X_4880_ _0629_ _0638_ VGND VGND VPWR VPWR _0639_ sky130_fd_sc_hd__xnor2_1
X_3900_ _3085_ _3091_ _3092_ VGND VGND VPWR VPWR _alu_i0.Datapath_i.fu_alu_33673_33851.out1\[14\]
+ sky130_fd_sc_hd__or3_1
X_3831_ _3024_ _3025_ VGND VGND VPWR VPWR _3026_ sky130_fd_sc_hd__nor2_1
XFILLER_32_365 VGND VGND VPWR VPWR sky130_fd_sc_hd__decap_3
X_3762_ net133 _2945_ _2958_ net122 VGND VGND VPWR VPWR _2961_ sky130_fd_sc_hd__a22o_1
XFILLER_20_516 VPWR VGND VPWR VGND sky130_ef_sc_hd__decap_12
XFILLER_32_376 VGND VGND VPWR VPWR sky130_fd_sc_hd__decap_4
X_6550_ _2447_ _2448_ VGND VGND VPWR VPWR _2449_ sky130_fd_sc_hd__nor2_1
XFILLER_9_561 VPWR VGND VPWR VGND sky130_ef_sc_hd__decap_12
X_5501_ _1171_ _1181_ _1180_ VGND VGND VPWR VPWR _1304_ sky130_fd_sc_hd__a21oi_1
X_3693_ net391 net209 VGND VGND VPWR VPWR _2894_ sky130_fd_sc_hd__nor2_1
X_6481_ _2363_ _2372_ VGND VGND VPWR VPWR _2373_ sky130_fd_sc_hd__xnor2_1
X_5432_ _1225_ _1226_ VGND VGND VPWR VPWR _1228_ sky130_fd_sc_hd__xnor2_1
XFILLER_105_109 VGND VGND VPWR VPWR sky130_fd_sc_hd__decap_3
XFILLER_99_321 VPWR VGND VPWR VGND sky130_ef_sc_hd__decap_12
X_5363_ net3 net187 VGND VGND VPWR VPWR _1153_ sky130_fd_sc_hd__and2_1
XFILLER_114_643 VGND VGND VPWR VPWR sky130_fd_sc_hd__fill_1
X_4314_ _2390_ _0083_ VGND VGND VPWR VPWR _0084_ sky130_fd_sc_hd__xnor2_1
XFILLER_113_153 VGND VGND VPWR VPWR sky130_fd_sc_hd__decap_4
X_5294_ _1075_ _1076_ _1043_ VGND VGND VPWR VPWR _1078_ sky130_fd_sc_hd__o21ba_1
XFILLER_113_197 VPWR VGND VPWR VGND sky130_ef_sc_hd__decap_12
XFILLER_59_229 VGND VGND VPWR VPWR sky130_fd_sc_hd__decap_6
X_4245_ _0017_ _0019_ _0020_ net138 net131 VGND VGND VPWR VPWR _0021_ sky130_fd_sc_hd__a221o_1
XFILLER_101_359 VPWR VGND VPWR VGND sky130_ef_sc_hd__decap_12
XFILLER_67_240 VGND VGND VPWR VPWR sky130_fd_sc_hd__fill_2
XFILLER_19_39 VPWR VGND VPWR VGND sky130_ef_sc_hd__decap_12
X_4176_ net142 _3350_ _3355_ net134 VGND VGND VPWR VPWR _3356_ sky130_fd_sc_hd__o211a_1
XFILLER_27_104 VGND VGND VPWR VPWR sky130_fd_sc_hd__decap_4
XFILLER_27_137 VGND VGND VPWR VPWR sky130_fd_sc_hd__decap_4
XFILLER_82_265 VPWR VGND VPWR VGND sky130_ef_sc_hd__decap_12
XFILLER_70_405 VGND VGND VPWR VPWR sky130_fd_sc_hd__fill_2
XFILLER_35_27 VPWR VGND VPWR VGND sky130_ef_sc_hd__decap_12
XFILLER_35_181 VGND VGND VPWR VPWR sky130_fd_sc_hd__decap_4
XFILLER_51_641 VPWR VGND VPWR VGND sky130_ef_sc_hd__decap_12
XFILLER_11_505 VPWR VGND VPWR VGND sky130_ef_sc_hd__decap_12
X_6817_ _2733_ _2738_ VGND VGND VPWR VPWR _2740_ sky130_fd_sc_hd__xnor2_1
XTAP_TAPCELL_ROW_21_500 VGND VPWR sky130_fd_sc_hd__tapvpwrvgnd_1
XFILLER_51_685 VGND VGND VPWR VPWR sky130_fd_sc_hd__decap_6
X_6748_ _2658_ _2660_ _2661_ _2662_ VGND VGND VPWR VPWR _2665_ sky130_fd_sc_hd__o211ai_1
XFILLER_50_195 VGND VGND VPWR VPWR sky130_fd_sc_hd__fill_1
XTAP_TAPCELL_ROW_98_1432 VGND VPWR sky130_fd_sc_hd__tapvpwrvgnd_1
X_6679_ _2587_ _2588_ _2572_ VGND VGND VPWR VPWR _2589_ sky130_fd_sc_hd__o21a_1
XFILLER_116_41 VPWR VGND VPWR VGND sky130_ef_sc_hd__decap_12
XFILLER_105_665 VGND VGND VPWR VPWR sky130_fd_sc_hd__decap_6
XFILLER_104_153 VGND VGND VPWR VPWR sky130_fd_sc_hd__decap_4
XFILLER_116_85 VPWR VGND VPWR VGND sky130_ef_sc_hd__decap_12
XFILLER_104_197 VPWR VGND VPWR VGND sky130_ef_sc_hd__decap_12
XFILLER_76_45 VPWR VGND VPWR VGND sky130_ef_sc_hd__decap_12
XTAP_TAPCELL_ROW_29_600 VGND VPWR sky130_fd_sc_hd__tapvpwrvgnd_1
XFILLER_46_413 VGND VGND VPWR VPWR sky130_fd_sc_hd__fill_1
XTAP_TAPCELL_ROW_57_931 VGND VPWR sky130_fd_sc_hd__tapvpwrvgnd_1
XFILLER_73_265 VPWR VGND VPWR VGND sky130_ef_sc_hd__decap_12
XFILLER_61_405 VPWR VGND VPWR VGND sky130_ef_sc_hd__decap_12
XFILLER_27_671 VGND VGND VPWR VPWR sky130_fd_sc_hd__fill_1
XFILLER_61_449 VGND VGND VPWR VPWR sky130_fd_sc_hd__fill_2
XFILLER_41_184 VGND VGND VPWR VPWR sky130_fd_sc_hd__fill_2
XFILLER_41_92 VGND VGND VPWR VPWR sky130_fd_sc_hd__fill_1
XFILLER_115_429 VPWR VGND VPWR VGND sky130_ef_sc_hd__decap_12
XTAP_TAPCELL_ROW_71_1104 VGND VPWR sky130_fd_sc_hd__tapvpwrvgnd_1
XPHY_EDGE_ROW_10_Right_10 VGND VGND VPWR VPWR sky130_fd_sc_hd__decap_3
XFILLER_2_53 VPWR VGND VPWR VGND sky130_ef_sc_hd__decap_12
X_4030_ net136 _3198_ _3208_ _3216_ net129 VGND VGND VPWR VPWR _3217_ sky130_fd_sc_hd__o221a_1
XFILLER_64_243 VGND VGND VPWR VPWR sky130_fd_sc_hd__decap_8
XFILLER_37_435 VGND VGND VPWR VPWR sky130_fd_sc_hd__decap_4
XFILLER_92_585 VGND VGND VPWR VPWR sky130_fd_sc_hd__decap_3
XTAP_TAPCELL_ROW_69_1077 VGND VPWR sky130_fd_sc_hd__tapvpwrvgnd_1
X_5981_ _1825_ _1826_ _1821_ VGND VGND VPWR VPWR _1828_ sky130_fd_sc_hd__a21o_1
X_4932_ _0688_ _0689_ _0604_ _0608_ VGND VGND VPWR VPWR _0691_ sky130_fd_sc_hd__a211oi_1
XTAP_TAPCELL_ROW_82_1233 VGND VPWR sky130_fd_sc_hd__tapvpwrvgnd_1
XFILLER_33_641 VPWR VGND VPWR VGND sky130_ef_sc_hd__decap_12
XTAP_TAPCELL_ROW_35_669 VGND VPWR sky130_fd_sc_hd__tapvpwrvgnd_1
X_4863_ net457 net321 net316 net474 VGND VGND VPWR VPWR _0622_ sky130_fd_sc_hd__a22o_1
XANTENNA_14 start_port VGND VGND VPWR VPWR sky130_fd_sc_hd__diode_2
X_6602_ _2500_ _2502_ _2503_ VGND VGND VPWR VPWR _2504_ sky130_fd_sc_hd__and3_1
XFILLER_20_302 VGND VGND VPWR VPWR sky130_fd_sc_hd__decap_6
XFILLER_20_324 VPWR VGND VPWR VGND sky130_ef_sc_hd__decap_12
XFILLER_32_173 VPWR VGND VPWR VGND sky130_ef_sc_hd__decap_12
XFILLER_33_685 VGND VGND VPWR VPWR sky130_fd_sc_hd__decap_6
X_4794_ _0480_ _0482_ _0481_ VGND VGND VPWR VPWR _0554_ sky130_fd_sc_hd__a21bo_1
XANTENNA_36 net475 VGND VGND VPWR VPWR sky130_fd_sc_hd__diode_2
X_3814_ _3006_ _3008_ net123 VGND VGND VPWR VPWR _3010_ sky130_fd_sc_hd__o21a_1
XANTENNA_25 net321 VGND VGND VPWR VPWR sky130_fd_sc_hd__diode_2
X_3745_ net370 net196 VGND VGND VPWR VPWR _2944_ sky130_fd_sc_hd__nor2_1
X_6533_ net222 net436 net435 net234 VGND VGND VPWR VPWR _2430_ sky130_fd_sc_hd__a22o_1
X_6464_ _2343_ _2352_ VGND VGND VPWR VPWR _2354_ sky130_fd_sc_hd__xnor2_1
X_5415_ _0990_ _0992_ _1095_ _1094_ VGND VGND VPWR VPWR _1210_ sky130_fd_sc_hd__a31o_1
X_3676_ _2872_ _2874_ VGND VGND VPWR VPWR _2878_ sky130_fd_sc_hd__xnor2_1
X_6395_ _2276_ _2277_ VGND VGND VPWR VPWR _2279_ sky130_fd_sc_hd__xor2_1
XFILLER_102_613 VPWR VGND VPWR VGND sky130_ef_sc_hd__decap_12
XTAP_TAPCELL_ROW_93_1373 VGND VPWR sky130_fd_sc_hd__tapvpwrvgnd_1
XTAP_TAPCELL_ROW_93_1362 VGND VPWR sky130_fd_sc_hd__tapvpwrvgnd_1
X_5346_ _1130_ _1131_ _1021_ _1024_ VGND VGND VPWR VPWR _1134_ sky130_fd_sc_hd__o211ai_2
XTAP_TAPCELL_ROW_7_339 VGND VPWR sky130_fd_sc_hd__tapvpwrvgnd_1
XFILLER_87_335 VGND VGND VPWR VPWR sky130_fd_sc_hd__fill_1
X_5277_ net404 net322 _0959_ _0957_ VGND VGND VPWR VPWR _1060_ sky130_fd_sc_hd__a31o_1
XFILLER_102_657 VPWR VGND VPWR VGND sky130_ef_sc_hd__decap_12
X_4228_ net232 _0004_ VGND VGND VPWR VPWR _0005_ sky130_fd_sc_hd__or2_1
XFILLER_101_189 VGND VGND VPWR VPWR sky130_fd_sc_hd__decap_4
XFILLER_101_167 VGND VGND VPWR VPWR sky130_fd_sc_hd__fill_1
XPHY_EDGE_ROW_106_Right_106 VGND VGND VPWR VPWR sky130_fd_sc_hd__decap_3
XFILLER_83_552 VGND VGND VPWR VPWR sky130_fd_sc_hd__decap_8
XFILLER_28_457 VGND VGND VPWR VPWR sky130_fd_sc_hd__decap_3
X_4159_ _3315_ _3333_ _3338_ _3339_ net125 VGND VGND VPWR VPWR _3340_ sky130_fd_sc_hd__o311a_1
XTAP_TAPCELL_ROW_54_901 VGND VPWR sky130_fd_sc_hd__tapvpwrvgnd_1
XFILLER_83_596 VPWR VGND VPWR VGND sky130_ef_sc_hd__decap_12
XFILLER_43_427 VGND VGND VPWR VPWR sky130_fd_sc_hd__decap_8
XFILLER_43_449 VPWR VGND VPWR VGND sky130_ef_sc_hd__decap_12
XFILLER_102_65 VGND VGND VPWR VPWR sky130_fd_sc_hd__fill_1
XFILLER_23_151 VGND VGND VPWR VPWR sky130_fd_sc_hd__decap_4
XTAP_TAPCELL_ROW_102_1480 VGND VPWR sky130_fd_sc_hd__tapvpwrvgnd_1
XFILLER_109_267 VPWR VGND VPWR VGND sky130_ef_sc_hd__decap_12
XFILLER_11_51 VGND VGND VPWR VPWR sky130_fd_sc_hd__decap_4
XFILLER_87_22 VPWR VGND VPWR VGND sky130_ef_sc_hd__decap_12
XFILLER_105_495 VGND VGND VPWR VPWR sky130_fd_sc_hd__decap_8
XFILLER_87_55 VGND VGND VPWR VPWR sky130_fd_sc_hd__fill_1
XFILLER_78_346 VGND VGND VPWR VPWR sky130_fd_sc_hd__fill_1
XFILLER_66_508 VGND VGND VPWR VPWR sky130_fd_sc_hd__decap_8
Xfanout370 net371 VGND VGND VPWR VPWR net370 sky130_fd_sc_hd__clkbuf_4
Xfanout392 net29 VGND VGND VPWR VPWR net392 sky130_fd_sc_hd__clkbuf_4
Xfanout381 net30 VGND VGND VPWR VPWR net381 sky130_fd_sc_hd__buf_4
XFILLER_93_349 VPWR VGND VPWR VGND sky130_ef_sc_hd__decap_12
XTAP_TAPCELL_ROW_105_1509 VGND VPWR sky130_fd_sc_hd__tapvpwrvgnd_1
XFILLER_46_243 VGND VGND VPWR VPWR sky130_fd_sc_hd__fill_1
XFILLER_61_257 VGND VGND VPWR VPWR sky130_fd_sc_hd__decap_8
XFILLER_15_641 VPWR VGND VPWR VGND sky130_ef_sc_hd__decap_12
XFILLER_61_279 VGND VGND VPWR VPWR sky130_fd_sc_hd__fill_1
XFILLER_15_685 VGND VGND VPWR VPWR sky130_fd_sc_hd__decap_4
XTAP_TAPCELL_ROW_32_639 VGND VPWR sky130_fd_sc_hd__tapvpwrvgnd_1
XFILLER_42_482 VGND VGND VPWR VPWR sky130_fd_sc_hd__fill_1
XFILLER_30_633 VGND VGND VPWR VPWR sky130_fd_sc_hd__decap_8
Xinput12 a[1] VGND VGND VPWR VPWR net12 sky130_fd_sc_hd__clkbuf_1
Xinput34 b[10] VGND VGND VPWR VPWR net34 sky130_fd_sc_hd__dlymetal6s2s_1
X_3530_ _2117_ VGND VGND VPWR VPWR _2128_ sky130_fd_sc_hd__inv_2
XTAP_TAPCELL_ROW_12_396 VGND VPWR sky130_fd_sc_hd__tapvpwrvgnd_1
Xinput45 b[20] VGND VGND VPWR VPWR net45 sky130_fd_sc_hd__clkbuf_1
Xinput23 a[2] VGND VGND VPWR VPWR net23 sky130_fd_sc_hd__clkbuf_2
XTAP_TAPCELL_ROW_116_1649 VGND VPWR sky130_fd_sc_hd__tapvpwrvgnd_1
XTAP_TAPCELL_ROW_116_1638 VGND VPWR sky130_fd_sc_hd__tapvpwrvgnd_1
Xinput67 opcode[1] VGND VGND VPWR VPWR net67 sky130_fd_sc_hd__clkbuf_2
Xinput56 b[30] VGND VGND VPWR VPWR net56 sky130_fd_sc_hd__clkbuf_4
XFILLER_115_237 VGND VGND VPWR VPWR sky130_fd_sc_hd__decap_8
X_3461_ net351 _0863_ _1364_ VGND VGND VPWR VPWR _1375_ sky130_fd_sc_hd__o21ai_1
X_5200_ _0827_ _0974_ VGND VGND VPWR VPWR _0976_ sky130_fd_sc_hd__xor2_1
X_6180_ _2041_ _2042_ VGND VGND VPWR VPWR _2044_ sky130_fd_sc_hd__and2_1
XFILLER_42_3 VPWR VGND VPWR VGND sky130_ef_sc_hd__decap_12
X_5131_ _0896_ _0897_ _0898_ VGND VGND VPWR VPWR _0900_ sky130_fd_sc_hd__a21oi_1
X_5062_ _0726_ _0823_ VGND VGND VPWR VPWR _0825_ sky130_fd_sc_hd__nand2_1
XFILLER_111_465 VPWR VGND VPWR VGND sky130_ef_sc_hd__decap_12
XFILLER_69_379 VPWR VGND VPWR VGND sky130_ef_sc_hd__decap_12
X_4013_ _3198_ _3199_ VGND VGND VPWR VPWR _3200_ sky130_fd_sc_hd__and2_1
XFILLER_84_338 VGND VGND VPWR VPWR sky130_fd_sc_hd__decap_6
XFILLER_65_541 VPWR VGND VPWR VGND sky130_ef_sc_hd__decap_12
XFILLER_16_29 VPWR VGND VPWR VGND sky130_ef_sc_hd__decap_12
XFILLER_25_427 VGND VGND VPWR VPWR sky130_fd_sc_hd__fill_2
XFILLER_52_224 VGND VGND VPWR VPWR sky130_fd_sc_hd__decap_8
XFILLER_80_555 VPWR VGND VPWR VGND sky130_ef_sc_hd__decap_12
X_5964_ _1806_ _1807_ VGND VGND VPWR VPWR _1809_ sky130_fd_sc_hd__xor2_1
X_4915_ _0586_ _0589_ _0672_ _0673_ VGND VGND VPWR VPWR _0674_ sky130_fd_sc_hd__a211oi_2
X_5895_ _1588_ _1731_ VGND VGND VPWR VPWR _1733_ sky130_fd_sc_hd__nor2_1
XFILLER_40_419 VGND VGND VPWR VPWR sky130_fd_sc_hd__fill_1
X_4846_ _0602_ _0603_ net114 VGND VGND VPWR VPWR _0606_ sky130_fd_sc_hd__o21bai_1
XFILLER_20_165 VGND VGND VPWR VPWR sky130_fd_sc_hd__decap_3
X_4777_ _0464_ _0467_ _0535_ _0536_ VGND VGND VPWR VPWR _0538_ sky130_fd_sc_hd__a211o_1
X_6516_ _2404_ _2409_ VGND VGND VPWR VPWR _2411_ sky130_fd_sc_hd__xnor2_1
XFILLER_20_187 VGND VGND VPWR VPWR sky130_fd_sc_hd__decap_8
X_3728_ _2921_ _2923_ _2927_ VGND VGND VPWR VPWR _2928_ sky130_fd_sc_hd__o21a_1
X_3659_ net246 _2861_ VGND VGND VPWR VPWR _2862_ sky130_fd_sc_hd__nor2_1
X_6447_ net419 net253 net53 net451 VGND VGND VPWR VPWR _2336_ sky130_fd_sc_hd__a22oi_1
X_6378_ _2222_ _2223_ _2258_ _2260_ VGND VGND VPWR VPWR _2261_ sky130_fd_sc_hd__and4bb_2
XFILLER_102_421 VGND VGND VPWR VPWR sky130_fd_sc_hd__decap_3
X_5329_ net352 net450 _1115_ VGND VGND VPWR VPWR _1116_ sky130_fd_sc_hd__and3_1
XFILLER_87_176 VPWR VGND VPWR VGND sky130_ef_sc_hd__decap_12
XFILLER_57_36 VGND VGND VPWR VPWR sky130_fd_sc_hd__decap_6
XFILLER_102_498 VPWR VGND VPWR VGND sky130_ef_sc_hd__decap_12
XFILLER_28_210 VGND VGND VPWR VPWR sky130_fd_sc_hd__decap_4
XFILLER_16_405 VGND VGND VPWR VPWR sky130_fd_sc_hd__decap_6
XFILLER_83_393 VPWR VGND VPWR VGND sky130_ef_sc_hd__decap_12
XFILLER_73_46 VGND VGND VPWR VPWR sky130_fd_sc_hd__decap_8
XFILLER_56_596 VGND VGND VPWR VPWR sky130_fd_sc_hd__fill_1
XFILLER_28_276 VGND VGND VPWR VPWR sky130_fd_sc_hd__decap_3
XFILLER_73_57 VPWR VGND VPWR VGND sky130_ef_sc_hd__decap_12
XFILLER_43_268 VGND VGND VPWR VPWR sky130_fd_sc_hd__fill_2
XFILLER_24_493 VGND VGND VPWR VPWR sky130_fd_sc_hd__decap_8
XFILLER_8_637 VGND VGND VPWR VPWR sky130_fd_sc_hd__decap_6
XFILLER_11_187 VGND VGND VPWR VPWR sky130_fd_sc_hd__decap_8
XFILLER_7_169 VPWR VGND VPWR VGND sky130_ef_sc_hd__decap_12
XTAP_TAPCELL_ROW_111_1579 VGND VPWR sky130_fd_sc_hd__tapvpwrvgnd_1
XFILLER_105_292 VGND VGND VPWR VPWR sky130_fd_sc_hd__decap_8
XFILLER_94_625 VPWR VGND VPWR VGND sky130_ef_sc_hd__decap_12
XFILLER_93_113 VPWR VGND VPWR VGND sky130_ef_sc_hd__decap_12
XFILLER_78_165 VPWR VGND VPWR VGND sky130_ef_sc_hd__decap_12
XFILLER_94_669 VPWR VGND VPWR VGND sky130_ef_sc_hd__decap_12
XFILLER_47_552 VGND VGND VPWR VPWR sky130_fd_sc_hd__decap_8
XFILLER_62_533 VGND VGND VPWR VPWR sky130_fd_sc_hd__fill_2
XFILLER_62_522 VGND VGND VPWR VPWR sky130_fd_sc_hd__fill_2
XTAP_TAPCELL_ROW_66_1047 VGND VPWR sky130_fd_sc_hd__tapvpwrvgnd_1
XTAP_TAPCELL_ROW_17_455 VGND VPWR sky130_fd_sc_hd__tapvpwrvgnd_1
XFILLER_22_419 VGND VGND VPWR VPWR sky130_fd_sc_hd__fill_1
XTAP_TAPCELL_ROW_45_786 VGND VPWR sky130_fd_sc_hd__tapvpwrvgnd_1
XTAP_TAPCELL_ROW_45_797 VGND VPWR sky130_fd_sc_hd__tapvpwrvgnd_1
X_4700_ _0459_ _0460_ _0387_ VGND VGND VPWR VPWR _0462_ sky130_fd_sc_hd__nor3b_2
X_5680_ _1488_ _1498_ VGND VGND VPWR VPWR _1499_ sky130_fd_sc_hd__xnor2_1
X_4631_ _0389_ _0391_ _0327_ VGND VGND VPWR VPWR _0394_ sky130_fd_sc_hd__a21o_1
XFILLER_8_41 VPWR VGND VPWR VGND sky130_ef_sc_hd__decap_12
XFILLER_30_452 VPWR VGND VPWR VGND sky130_ef_sc_hd__decap_12
XFILLER_8_85 VPWR VGND VPWR VGND sky130_ef_sc_hd__decap_12
X_4562_ _0323_ _0324_ _0295_ VGND VGND VPWR VPWR _0326_ sky130_fd_sc_hd__a21o_1
X_4493_ _0256_ _0257_ VGND VGND VPWR VPWR _0258_ sky130_fd_sc_hd__and2b_1
X_3513_ _1168_ _1898_ VGND VGND VPWR VPWR _1942_ sky130_fd_sc_hd__nand2_1
X_6301_ _2174_ _2175_ VGND VGND VPWR VPWR _2176_ sky130_fd_sc_hd__or2_1
XTAP_TAPCELL_ROW_77_1176 VGND VPWR sky130_fd_sc_hd__tapvpwrvgnd_1
X_3444_ _0776_ net179 _1037_ VGND VGND VPWR VPWR _1190_ sky130_fd_sc_hd__and3_1
X_6232_ _2085_ _2099_ _2100_ VGND VGND VPWR VPWR _2101_ sky130_fd_sc_hd__nor3_1
XTAP_TAPCELL_ROW_90_1332 VGND VPWR sky130_fd_sc_hd__tapvpwrvgnd_1
XFILLER_97_441 VGND VGND VPWR VPWR sky130_fd_sc_hd__decap_6
X_6163_ net405 net266 VGND VGND VPWR VPWR _2025_ sky130_fd_sc_hd__nand2_1
X_5114_ _0744_ _0746_ _0880_ _0881_ VGND VGND VPWR VPWR _0882_ sky130_fd_sc_hd__a211oi_2
X_6094_ net223 net444 net441 net235 VGND VGND VPWR VPWR _1950_ sky130_fd_sc_hd__a22oi_1
XFILLER_97_496 VGND VGND VPWR VPWR sky130_fd_sc_hd__fill_2
X_5045_ _0803_ _0804_ _0805_ VGND VGND VPWR VPWR _0806_ sky130_fd_sc_hd__and3_1
XFILLER_27_39 VPWR VGND VPWR VGND sky130_ef_sc_hd__decap_12
XFILLER_93_691 VGND VGND VPWR VPWR sky130_fd_sc_hd__fill_1
XFILLER_65_393 VPWR VGND VPWR VGND sky130_ef_sc_hd__decap_12
XFILLER_38_596 VPWR VGND VPWR VGND sky130_ef_sc_hd__decap_12
X_5947_ _1608_ _1788_ _1789_ VGND VGND VPWR VPWR _1791_ sky130_fd_sc_hd__and3_1
XFILLER_80_396 VPWR VGND VPWR VGND sky130_ef_sc_hd__decap_12
X_5878_ _1586_ _1713_ VGND VGND VPWR VPWR _1716_ sky130_fd_sc_hd__xnor2_1
X_4829_ _0580_ _0586_ _0587_ VGND VGND VPWR VPWR _0589_ sky130_fd_sc_hd__nand3_2
XFILLER_107_502 VGND VGND VPWR VPWR sky130_fd_sc_hd__fill_2
XFILLER_5_629 VPWR VGND VPWR VGND sky130_ef_sc_hd__decap_12
XFILLER_4_106 VGND VGND VPWR VPWR sky130_fd_sc_hd__fill_2
XFILLER_4_139 VGND VGND VPWR VPWR sky130_fd_sc_hd__fill_1
XFILLER_108_53 VPWR VGND VPWR VGND sky130_ef_sc_hd__decap_12
XFILLER_108_97 VPWR VGND VPWR VGND sky130_ef_sc_hd__decap_12
XFILLER_48_305 VGND VGND VPWR VPWR sky130_fd_sc_hd__decap_3
XFILLER_76_669 VPWR VGND VPWR VGND sky130_ef_sc_hd__decap_12
XFILLER_75_113 VGND VGND VPWR VPWR sky130_fd_sc_hd__decap_4
XFILLER_91_617 VPWR VGND VPWR VGND sky130_ef_sc_hd__decap_12
XFILLER_84_45 VGND VGND VPWR VPWR sky130_fd_sc_hd__fill_1
XFILLER_75_157 VGND VGND VPWR VPWR sky130_fd_sc_hd__decap_8
XFILLER_90_116 VPWR VGND VPWR VGND sky130_ef_sc_hd__decap_12
XFILLER_29_585 VGND VGND VPWR VPWR sky130_fd_sc_hd__decap_3
XFILLER_44_533 VPWR VGND VPWR VGND sky130_ef_sc_hd__decap_12
XTAP_TAPCELL_ROW_14_414 VGND VPWR sky130_fd_sc_hd__tapvpwrvgnd_1
XTAP_TAPCELL_ROW_14_425 VGND VPWR sky130_fd_sc_hd__tapvpwrvgnd_1
XTAP_TAPCELL_ROW_42_756 VGND VPWR sky130_fd_sc_hd__tapvpwrvgnd_1
XFILLER_12_496 VGND VGND VPWR VPWR sky130_fd_sc_hd__decap_8
XFILLER_8_445 VPWR VGND VPWR VGND sky130_ef_sc_hd__decap_12
XFILLER_33_93 VPWR VGND VPWR VGND sky130_ef_sc_hd__decap_12
XFILLER_69_8 VPWR VGND VPWR VGND sky130_ef_sc_hd__decap_12
XFILLER_8_489 VPWR VGND VPWR VGND sky130_ef_sc_hd__decap_12
XFILLER_113_505 VPWR VGND VPWR VGND sky130_ef_sc_hd__decap_12
XTAP_TAPCELL_ROW_113_1608 VGND VPWR sky130_fd_sc_hd__tapvpwrvgnd_1
XFILLER_67_658 VPWR VGND VPWR VGND sky130_ef_sc_hd__decap_12
XFILLER_94_477 VPWR VGND VPWR VGND sky130_ef_sc_hd__decap_12
XFILLER_75_691 VGND VGND VPWR VPWR sky130_fd_sc_hd__fill_1
X_6850_ _2751_ _2775_ VGND VGND VPWR VPWR _2776_ sky130_fd_sc_hd__xnor2_1
XFILLER_47_393 VPWR VGND VPWR VGND sky130_ef_sc_hd__decap_12
XFILLER_62_352 VPWR VGND VPWR VGND sky130_ef_sc_hd__decap_12
X_5801_ net389 net302 _1472_ _1471_ VGND VGND VPWR VPWR _1631_ sky130_fd_sc_hd__a31o_1
XPHY_EDGE_ROW_8_Right_8 VGND VGND VPWR VPWR sky130_fd_sc_hd__decap_3
X_6781_ _2683_ _2699_ VGND VGND VPWR VPWR _2700_ sky130_fd_sc_hd__xnor2_1
X_5732_ _1553_ _1554_ _1543_ VGND VGND VPWR VPWR _1556_ sky130_fd_sc_hd__a21oi_2
X_3993_ _3171_ _3180_ VGND VGND VPWR VPWR _3181_ sky130_fd_sc_hd__nand2_1
XTAP_TAPCELL_ROW_79_1205 VGND VPWR sky130_fd_sc_hd__tapvpwrvgnd_1
X_5663_ _1461_ _1478_ _1479_ VGND VGND VPWR VPWR _1480_ sky130_fd_sc_hd__or3_1
XFILLER_30_260 VGND VGND VPWR VPWR sky130_fd_sc_hd__decap_4
XFILLER_30_271 VPWR VGND VPWR VGND sky130_ef_sc_hd__decap_12
X_4614_ _0372_ _0375_ _0376_ VGND VGND VPWR VPWR _0377_ sky130_fd_sc_hd__nand3_1
X_5594_ net429 net331 net325 net361 VGND VGND VPWR VPWR _1405_ sky130_fd_sc_hd__a22o_1
X_4545_ _0306_ _0307_ _0296_ VGND VGND VPWR VPWR _0309_ sky130_fd_sc_hd__a21o_1
XFILLER_116_365 VGND VGND VPWR VPWR sky130_fd_sc_hd__decap_4
XFILLER_104_527 VGND VGND VPWR VPWR sky130_fd_sc_hd__decap_4
X_4476_ net229 net399 net391 net242 VGND VGND VPWR VPWR _0241_ sky130_fd_sc_hd__a22o_1
X_6215_ _2072_ _2081_ VGND VGND VPWR VPWR _2082_ sky130_fd_sc_hd__and2_1
XPHY_EDGE_ROW_39_Right_39 VGND VGND VPWR VPWR sky130_fd_sc_hd__decap_3
X_3427_ net53 VGND VGND VPWR VPWR _1004_ sky130_fd_sc_hd__inv_2
XFILLER_85_411 VGND VGND VPWR VPWR sky130_fd_sc_hd__decap_6
XFILLER_38_27 VGND VGND VPWR VPWR sky130_fd_sc_hd__fill_1
X_6146_ _1814_ _1817_ _2005_ _2006_ VGND VGND VPWR VPWR _2007_ sky130_fd_sc_hd__o211ai_2
XFILLER_58_669 VPWR VGND VPWR VGND sky130_ef_sc_hd__decap_12
X_6077_ _1780_ _1782_ VGND VGND VPWR VPWR _1932_ sky130_fd_sc_hd__nand2_1
X_5028_ _0784_ _0785_ _0786_ VGND VGND VPWR VPWR _0789_ sky130_fd_sc_hd__nand3_1
XFILLER_72_149 VGND VGND VPWR VPWR sky130_fd_sc_hd__decap_3
XFILLER_54_26 VGND VGND VPWR VPWR sky130_fd_sc_hd__fill_2
XFILLER_26_533 VPWR VGND VPWR VGND sky130_ef_sc_hd__decap_12
XFILLER_41_503 VGND VGND VPWR VPWR sky130_fd_sc_hd__fill_1
XFILLER_41_525 VPWR VGND VPWR VGND sky130_ef_sc_hd__decap_12
XFILLER_13_249 VGND VGND VPWR VPWR sky130_fd_sc_hd__decap_3
XFILLER_41_558 VGND VGND VPWR VPWR sky130_fd_sc_hd__fill_2
XPHY_EDGE_ROW_48_Right_48 VGND VGND VPWR VPWR sky130_fd_sc_hd__decap_3
XFILLER_110_65 VPWR VGND VPWR VGND sky130_ef_sc_hd__decap_12
XFILLER_21_271 VGND VGND VPWR VPWR sky130_fd_sc_hd__decap_8
XPHY_EDGE_ROW_57_Right_57 VGND VGND VPWR VPWR sky130_fd_sc_hd__decap_3
XFILLER_1_665 VGND VGND VPWR VPWR sky130_fd_sc_hd__decap_6
XFILLER_95_55 VGND VGND VPWR VPWR sky130_fd_sc_hd__fill_1
XFILLER_76_433 VPWR VGND VPWR VGND sky130_ef_sc_hd__decap_12
XFILLER_48_113 VGND VGND VPWR VPWR sky130_fd_sc_hd__fill_2
XFILLER_76_477 VGND VGND VPWR VPWR sky130_fd_sc_hd__decap_8
XFILLER_64_639 VGND VGND VPWR VPWR sky130_fd_sc_hd__decap_4
XFILLER_57_691 VGND VGND VPWR VPWR sky130_fd_sc_hd__fill_1
XFILLER_17_500 VGND VGND VPWR VPWR sky130_fd_sc_hd__decap_4
XTAP_TAPCELL_ROW_47_815 VGND VPWR sky130_fd_sc_hd__tapvpwrvgnd_1
XFILLER_91_447 VGND VGND VPWR VPWR sky130_fd_sc_hd__fill_1
XFILLER_17_544 VPWR VGND VPWR VGND sky130_ef_sc_hd__decap_12
XFILLER_44_341 VGND VGND VPWR VPWR sky130_fd_sc_hd__decap_8
XPHY_EDGE_ROW_66_Right_66 VGND VGND VPWR VPWR sky130_fd_sc_hd__decap_3
XTAP_TAPCELL_ROW_63_1006 VGND VPWR sky130_fd_sc_hd__tapvpwrvgnd_1
XFILLER_44_363 VGND VGND VPWR VPWR sky130_fd_sc_hd__fill_1
XTAP_TAPCELL_ROW_27_572 VGND VPWR sky130_fd_sc_hd__tapvpwrvgnd_1
XFILLER_44_92 VGND VGND VPWR VPWR sky130_fd_sc_hd__fill_1
XFILLER_8_242 VGND VGND VPWR VPWR sky130_fd_sc_hd__decap_4
XPHY_EDGE_ROW_75_Right_75 VGND VGND VPWR VPWR sky130_fd_sc_hd__decap_3
X_4330_ _2717_ _0074_ _0072_ VGND VGND VPWR VPWR _0099_ sky130_fd_sc_hd__a21o_1
XTAP_TAPCELL_ROW_74_1135 VGND VPWR sky130_fd_sc_hd__tapvpwrvgnd_1
X_4261_ net144 _0029_ net138 VGND VGND VPWR VPWR _0036_ sky130_fd_sc_hd__a21o_1
X_6000_ _1656_ net110 _1846_ _1847_ VGND VGND VPWR VPWR _1848_ sky130_fd_sc_hd__o211a_1
XFILLER_79_293 VPWR VGND VPWR VGND sky130_ef_sc_hd__decap_12
XFILLER_39_113 VGND VGND VPWR VPWR sky130_fd_sc_hd__decap_8
X_4192_ _3369_ _3370_ VGND VGND VPWR VPWR _3371_ sky130_fd_sc_hd__or2_2
XFILLER_67_444 VGND VGND VPWR VPWR sky130_fd_sc_hd__decap_4
XFILLER_55_617 VPWR VGND VPWR VGND sky130_ef_sc_hd__decap_12
XPHY_EDGE_ROW_84_Right_84 VGND VGND VPWR VPWR sky130_fd_sc_hd__decap_3
XFILLER_82_425 VGND VGND VPWR VPWR sky130_fd_sc_hd__fill_1
XPHY_EDGE_ROW_19_Left_136 VGND VGND VPWR VPWR sky130_fd_sc_hd__decap_3
X_6902_ net182 _alu_i0.Datapath_i.fu_alu_33673_33851.out1\[28\] VGND VGND VPWR VPWR
+ _alu_i0.Datapath_i.reg_0.reg_out1\[28\] sky130_fd_sc_hd__dfxtp_1
XTAP_TAPCELL_ROW_85_1275 VGND VPWR sky130_fd_sc_hd__tapvpwrvgnd_1
X_6833_ _2752_ _2756_ VGND VGND VPWR VPWR _2757_ sky130_fd_sc_hd__xnor2_1
XFILLER_23_547 VPWR VGND VPWR VGND sky130_ef_sc_hd__decap_12
XFILLER_24_29 VPWR VGND VPWR VGND sky130_ef_sc_hd__decap_12
X_6764_ _2672_ _2680_ VGND VGND VPWR VPWR _2681_ sky130_fd_sc_hd__xnor2_1
X_3976_ _3146_ _3164_ _3162_ VGND VGND VPWR VPWR _3165_ sky130_fd_sc_hd__o21ai_1
XFILLER_50_344 VGND VGND VPWR VPWR sky130_fd_sc_hd__fill_1
X_6695_ _2604_ _2605_ VGND VGND VPWR VPWR _2606_ sky130_fd_sc_hd__xnor2_1
X_5715_ _1535_ _1536_ VGND VGND VPWR VPWR _1537_ sky130_fd_sc_hd__xnor2_2
X_5646_ net469 net267 VGND VGND VPWR VPWR _1461_ sky130_fd_sc_hd__nand2_1
XPHY_EDGE_ROW_28_Left_145 VGND VGND VPWR VPWR sky130_fd_sc_hd__decap_3
XFILLER_31_591 VGND VGND VPWR VPWR sky130_fd_sc_hd__fill_1
XFILLER_108_118 VGND VGND VPWR VPWR sky130_fd_sc_hd__fill_1
XPHY_EDGE_ROW_93_Right_93 VGND VGND VPWR VPWR sky130_fd_sc_hd__decap_3
X_5577_ net403 net299 net294 net411 VGND VGND VPWR VPWR _1387_ sky130_fd_sc_hd__a22oi_1
X_4528_ net457 net191 net345 net474 VGND VGND VPWR VPWR _0292_ sky130_fd_sc_hd__a22o_1
X_4459_ _0222_ _0223_ _0177_ VGND VGND VPWR VPWR _0225_ sky130_fd_sc_hd__o21a_1
XFILLER_77_208 VGND VGND VPWR VPWR sky130_fd_sc_hd__decap_4
XFILLER_58_433 VPWR VGND VPWR VGND sky130_ef_sc_hd__decap_12
XFILLER_85_230 VPWR VGND VPWR VGND sky130_ef_sc_hd__decap_12
X_6129_ _1967_ _1987_ _1988_ VGND VGND VPWR VPWR _1989_ sky130_fd_sc_hd__and3_1
XPHY_EDGE_ROW_37_Left_154 VGND VGND VPWR VPWR sky130_fd_sc_hd__decap_3
XFILLER_105_87 VGND VGND VPWR VPWR sky130_fd_sc_hd__fill_1
XFILLER_58_499 VGND VGND VPWR VPWR sky130_fd_sc_hd__decap_8
XFILLER_58_477 VPWR VGND VPWR VGND sky130_ef_sc_hd__decap_12
XFILLER_45_105 VGND VGND VPWR VPWR sky130_fd_sc_hd__fill_1
XFILLER_73_447 VGND VGND VPWR VPWR sky130_fd_sc_hd__fill_1
XFILLER_65_69 VGND VGND VPWR VPWR sky130_fd_sc_hd__decap_6
XFILLER_39_691 VGND VGND VPWR VPWR sky130_fd_sc_hd__fill_1
XFILLER_14_503 VGND VGND VPWR VPWR sky130_fd_sc_hd__decap_8
XFILLER_26_363 VGND VGND VPWR VPWR sky130_fd_sc_hd__fill_1
XFILLER_14_569 VPWR VGND VPWR VGND sky130_ef_sc_hd__decap_12
XTAP_TAPCELL_ROW_24_542 VGND VPWR sky130_fd_sc_hd__tapvpwrvgnd_1
XFILLER_41_388 VGND VGND VPWR VPWR sky130_fd_sc_hd__decap_4
XPHY_EDGE_ROW_46_Left_163 VGND VGND VPWR VPWR sky130_fd_sc_hd__decap_3
XTAP_TAPCELL_ROW_52_873 VGND VPWR sky130_fd_sc_hd__tapvpwrvgnd_1
XFILLER_5_223 VGND VGND VPWR VPWR sky130_fd_sc_hd__fill_1
XFILLER_107_162 VGND VGND VPWR VPWR sky130_fd_sc_hd__fill_1
XFILLER_5_289 VGND VGND VPWR VPWR sky130_fd_sc_hd__fill_2
XFILLER_5_278 VGND VGND VPWR VPWR sky130_fd_sc_hd__fill_2
XFILLER_30_83 VGND VGND VPWR VPWR sky130_fd_sc_hd__fill_1
XFILLER_96_528 VGND VGND VPWR VPWR sky130_fd_sc_hd__decap_4
XPHY_EDGE_ROW_55_Left_172 VGND VGND VPWR VPWR sky130_fd_sc_hd__decap_3
XFILLER_96_539 VGND VGND VPWR VPWR sky130_fd_sc_hd__decap_3
XFILLER_1_473 VGND VGND VPWR VPWR sky130_fd_sc_hd__fill_1
XFILLER_64_425 VGND VGND VPWR VPWR sky130_fd_sc_hd__fill_1
XFILLER_64_414 VGND VGND VPWR VPWR sky130_fd_sc_hd__decap_6
XFILLER_36_105 VGND VGND VPWR VPWR sky130_fd_sc_hd__fill_1
XFILLER_37_617 VPWR VGND VPWR VGND sky130_ef_sc_hd__decap_12
XFILLER_51_108 VGND VGND VPWR VPWR sky130_fd_sc_hd__fill_1
X_3830_ net311 net335 VGND VGND VPWR VPWR _3025_ sky130_fd_sc_hd__nor2_1
XPHY_EDGE_ROW_64_Left_181 VGND VGND VPWR VPWR sky130_fd_sc_hd__decap_3
XFILLER_44_193 VGND VGND VPWR VPWR sky130_fd_sc_hd__decap_3
X_3761_ net151 _1266_ VGND VGND VPWR VPWR _2960_ sky130_fd_sc_hd__nand2_1
XFILLER_20_528 VGND VGND VPWR VPWR sky130_fd_sc_hd__decap_4
X_5500_ _1293_ _1302_ VGND VGND VPWR VPWR _1303_ sky130_fd_sc_hd__xnor2_1
X_3692_ net391 net209 VGND VGND VPWR VPWR _2893_ sky130_fd_sc_hd__and2_1
XFILLER_72_3 VPWR VGND VPWR VGND sky130_ef_sc_hd__decap_12
X_6480_ _2369_ _2370_ VGND VGND VPWR VPWR _2372_ sky130_fd_sc_hd__xnor2_1
XFILLER_9_573 VPWR VGND VPWR VGND sky130_ef_sc_hd__decap_12
X_5431_ _1225_ _1226_ VGND VGND VPWR VPWR _1227_ sky130_fd_sc_hd__or2_1
X_5362_ _1144_ _1150_ VGND VGND VPWR VPWR _1152_ sky130_fd_sc_hd__xnor2_1
XFILLER_99_333 VGND VGND VPWR VPWR sky130_fd_sc_hd__decap_3
X_4313_ _0060_ _0081_ VGND VGND VPWR VPWR _0083_ sky130_fd_sc_hd__xor2_1
XPHY_EDGE_ROW_73_Left_190 VGND VGND VPWR VPWR sky130_fd_sc_hd__decap_3
XFILLER_99_388 VGND VGND VPWR VPWR sky130_fd_sc_hd__decap_4
X_5293_ _1075_ _1076_ _1043_ VGND VGND VPWR VPWR _1077_ sky130_fd_sc_hd__nor3b_1
X_4244_ net24 net56 VGND VGND VPWR VPWR _0020_ sky130_fd_sc_hd__or2_1
XFILLER_95_561 VPWR VGND VPWR VGND sky130_ef_sc_hd__decap_12
X_4175_ _3331_ _3339_ _3353_ _3354_ _1887_ VGND VGND VPWR VPWR _3355_ sky130_fd_sc_hd__a311o_1
XFILLER_67_263 VGND VGND VPWR VPWR sky130_fd_sc_hd__decap_6
XFILLER_55_447 VGND VGND VPWR VPWR sky130_fd_sc_hd__fill_1
XFILLER_82_277 VGND VGND VPWR VPWR sky130_fd_sc_hd__decap_8
XFILLER_35_39 VPWR VGND VPWR VGND sky130_ef_sc_hd__decap_12
XFILLER_23_311 VGND VGND VPWR VPWR sky130_fd_sc_hd__fill_1
XFILLER_35_160 VGND VGND VPWR VPWR sky130_fd_sc_hd__decap_8
X_6816_ _2735_ _2737_ VGND VGND VPWR VPWR _2738_ sky130_fd_sc_hd__xnor2_1
XFILLER_23_344 VPWR VGND VPWR VGND sky130_ef_sc_hd__decap_12
XFILLER_50_141 VPWR VGND VPWR VGND sky130_ef_sc_hd__decap_12
XFILLER_51_653 VPWR VGND VPWR VGND sky130_ef_sc_hd__decap_12
XFILLER_11_517 VPWR VGND VPWR VGND sky130_ef_sc_hd__decap_12
XTAP_TAPCELL_ROW_21_501 VGND VPWR sky130_fd_sc_hd__tapvpwrvgnd_1
X_6747_ _2661_ _2662_ _2658_ _2660_ VGND VGND VPWR VPWR _2664_ sky130_fd_sc_hd__a211o_1
XTAP_TAPCELL_ROW_98_1422 VGND VPWR sky130_fd_sc_hd__tapvpwrvgnd_1
X_3959_ net170 _0961_ _3144_ VGND VGND VPWR VPWR _3149_ sky130_fd_sc_hd__a21oi_1
XFILLER_51_49 VGND VGND VPWR VPWR sky130_fd_sc_hd__fill_1
XTAP_TAPCELL_ROW_98_1433 VGND VPWR sky130_fd_sc_hd__tapvpwrvgnd_1
X_6678_ _2410_ _2414_ _2585_ VGND VGND VPWR VPWR _2588_ sky130_fd_sc_hd__and3_1
X_5629_ _1254_ _1257_ _1442_ _1443_ VGND VGND VPWR VPWR _1444_ sky130_fd_sc_hd__o211ai_2
XFILLER_2_204 VGND VGND VPWR VPWR sky130_fd_sc_hd__fill_1
XFILLER_2_226 VPWR VGND VPWR VGND sky130_ef_sc_hd__decap_12
XFILLER_116_53 VGND VGND VPWR VPWR sky130_fd_sc_hd__decap_3
XFILLER_116_97 VPWR VGND VPWR VGND sky130_ef_sc_hd__decap_12
XFILLER_76_57 VPWR VGND VPWR VGND sky130_ef_sc_hd__decap_12
XFILLER_19_606 VGND VGND VPWR VPWR sky130_fd_sc_hd__decap_8
XFILLER_19_617 VPWR VGND VPWR VGND sky130_ef_sc_hd__decap_12
XTAP_TAPCELL_ROW_29_601 VGND VPWR sky130_fd_sc_hd__tapvpwrvgnd_1
XFILLER_100_382 VPWR VGND VPWR VGND sky130_ef_sc_hd__decap_12
XTAP_TAPCELL_ROW_57_932 VGND VPWR sky130_fd_sc_hd__tapvpwrvgnd_1
XTAP_TAPCELL_ROW_107_1540 VGND VPWR sky130_fd_sc_hd__tapvpwrvgnd_1
XFILLER_92_45 VGND VGND VPWR VPWR sky130_fd_sc_hd__fill_1
XFILLER_73_277 VGND VGND VPWR VPWR sky130_fd_sc_hd__decap_3
XFILLER_61_417 VPWR VGND VPWR VGND sky130_ef_sc_hd__decap_12
XFILLER_14_322 VGND VGND VPWR VPWR sky130_fd_sc_hd__decap_4
XFILLER_42_620 VPWR VGND VPWR VGND sky130_ef_sc_hd__decap_12
XFILLER_92_89 VPWR VGND VPWR VGND sky130_ef_sc_hd__decap_12
XFILLER_6_521 VGND VGND VPWR VPWR sky130_fd_sc_hd__decap_8
XFILLER_6_587 VGND VGND VPWR VPWR sky130_fd_sc_hd__fill_1
XTAP_TAPCELL_ROW_71_1105 VGND VPWR sky130_fd_sc_hd__tapvpwrvgnd_1
XFILLER_96_336 VGND VGND VPWR VPWR sky130_fd_sc_hd__fill_2
XFILLER_110_146 VGND VGND VPWR VPWR sky130_fd_sc_hd__fill_1
XFILLER_77_550 VGND VGND VPWR VPWR sky130_fd_sc_hd__decap_8
XFILLER_77_561 VGND VGND VPWR VPWR sky130_fd_sc_hd__decap_6
XFILLER_2_65 VPWR VGND VPWR VGND sky130_ef_sc_hd__decap_12
XFILLER_37_447 VGND VGND VPWR VPWR sky130_fd_sc_hd__fill_1
XTAP_TAPCELL_ROW_69_1078 VGND VPWR sky130_fd_sc_hd__tapvpwrvgnd_1
XFILLER_25_609 VGND VGND VPWR VPWR sky130_fd_sc_hd__decap_6
X_5980_ _1821_ _1825_ _1826_ VGND VGND VPWR VPWR _1827_ sky130_fd_sc_hd__nand3_2
X_4931_ _0604_ _0608_ _0688_ _0689_ VGND VGND VPWR VPWR _0690_ sky130_fd_sc_hd__o211a_1
XFILLER_64_288 VGND VGND VPWR VPWR sky130_fd_sc_hd__fill_1
XFILLER_52_439 VPWR VGND VPWR VGND sky130_ef_sc_hd__decap_12
X_4862_ _0620_ _0621_ _alu_i0.Datapath_i.reg_0.reg_out1\[14\] net150 VGND VGND VPWR
+ VPWR net82 sky130_fd_sc_hd__a2bb2o_1
XTAP_TAPCELL_ROW_82_1234 VGND VPWR sky130_fd_sc_hd__tapvpwrvgnd_1
XFILLER_33_653 VPWR VGND VPWR VGND sky130_ef_sc_hd__decap_12
X_3813_ _3006_ _3008_ VGND VGND VPWR VPWR _3009_ sky130_fd_sc_hd__nand2_1
XFILLER_60_461 VGND VGND VPWR VPWR sky130_fd_sc_hd__decap_8
X_6601_ net451 net54 net56 net468 VGND VGND VPWR VPWR _2503_ sky130_fd_sc_hd__a22o_1
X_4793_ _0549_ _0550_ _0551_ VGND VGND VPWR VPWR _0553_ sky130_fd_sc_hd__nand3_1
XANTENNA_26 net326 VGND VGND VPWR VPWR sky130_fd_sc_hd__diode_2
XFILLER_20_336 VPWR VGND VPWR VGND sky130_ef_sc_hd__decap_12
XANTENNA_37 net2 VGND VGND VPWR VPWR sky130_fd_sc_hd__diode_2
XANTENNA_15 net5 VGND VGND VPWR VPWR sky130_fd_sc_hd__diode_2
XFILLER_32_185 VGND VGND VPWR VPWR sky130_fd_sc_hd__decap_8
X_3744_ net372 net194 VGND VGND VPWR VPWR _2943_ sky130_fd_sc_hd__nand2_2
X_6532_ _2426_ _2427_ _2222_ _2261_ VGND VGND VPWR VPWR _2429_ sky130_fd_sc_hd__a211o_1
X_3675_ _2872_ _2875_ _2876_ VGND VGND VPWR VPWR _2877_ sky130_fd_sc_hd__a21oi_1
X_6463_ _2343_ _2352_ VGND VGND VPWR VPWR _2353_ sky130_fd_sc_hd__nand2b_1
XFILLER_106_419 VGND VGND VPWR VPWR sky130_fd_sc_hd__fill_1
X_5414_ _0990_ _1095_ _1094_ VGND VGND VPWR VPWR _1209_ sky130_fd_sc_hd__a21o_1
Xoutput100 net100 VGND VGND VPWR VPWR return_port[30] sky130_fd_sc_hd__clkbuf_4
X_6394_ _2276_ _2277_ VGND VGND VPWR VPWR _2278_ sky130_fd_sc_hd__nand2b_1
XTAP_TAPCELL_ROW_93_1363 VGND VPWR sky130_fd_sc_hd__tapvpwrvgnd_1
X_5345_ _1021_ _1024_ _1130_ _1131_ VGND VGND VPWR VPWR _1133_ sky130_fd_sc_hd__a211o_1
XFILLER_102_625 VPWR VGND VPWR VGND sky130_ef_sc_hd__decap_12
XFILLER_101_113 VPWR VGND VPWR VGND sky130_ef_sc_hd__decap_12
X_5276_ _1047_ _1057_ VGND VGND VPWR VPWR _1058_ sky130_fd_sc_hd__xnor2_1
XFILLER_102_669 VPWR VGND VPWR VGND sky130_ef_sc_hd__decap_12
X_4227_ _3326_ _3404_ net161 VGND VGND VPWR VPWR _0004_ sky130_fd_sc_hd__mux2_1
XFILLER_95_391 VGND VGND VPWR VPWR sky130_fd_sc_hd__fill_1
XFILLER_46_27 VGND VGND VPWR VPWR sky130_fd_sc_hd__fill_1
X_4158_ _3315_ _3338_ _3333_ VGND VGND VPWR VPWR _3339_ sky130_fd_sc_hd__o21ai_2
XTAP_TAPCELL_ROW_54_902 VGND VPWR sky130_fd_sc_hd__tapvpwrvgnd_1
X_4089_ net125 _3245_ _3249_ _3272_ VGND VGND VPWR VPWR _3273_ sky130_fd_sc_hd__a31o_1
XFILLER_70_214 VGND VGND VPWR VPWR sky130_fd_sc_hd__fill_1
XFILLER_70_203 VGND VGND VPWR VPWR sky130_fd_sc_hd__fill_1
XFILLER_43_439 VGND VGND VPWR VPWR sky130_fd_sc_hd__decap_8
XTAP_TAPCELL_ROW_102_1481 VGND VPWR sky130_fd_sc_hd__tapvpwrvgnd_1
XTAP_TAPCELL_ROW_102_1470 VGND VPWR sky130_fd_sc_hd__tapvpwrvgnd_1
XTAP_TAPCELL_ROW_62_990 VGND VPWR sky130_fd_sc_hd__tapvpwrvgnd_1
XFILLER_109_279 VGND VGND VPWR VPWR sky130_fd_sc_hd__fill_1
XFILLER_87_34 VGND VGND VPWR VPWR sky130_fd_sc_hd__decap_6
XFILLER_2_3 VPWR VGND VPWR VGND sky130_ef_sc_hd__decap_12
XFILLER_87_89 VPWR VGND VPWR VGND sky130_ef_sc_hd__decap_12
XFILLER_59_550 VGND VGND VPWR VPWR sky130_fd_sc_hd__decap_8
Xfanout393 net394 VGND VGND VPWR VPWR net393 sky130_fd_sc_hd__buf_2
Xfanout371 net373 VGND VGND VPWR VPWR net371 sky130_fd_sc_hd__clkbuf_4
XFILLER_59_561 VGND VGND VPWR VPWR sky130_fd_sc_hd__fill_2
Xfanout382 net384 VGND VGND VPWR VPWR net382 sky130_fd_sc_hd__buf_2
Xfanout360 net361 VGND VGND VPWR VPWR net360 sky130_fd_sc_hd__clkbuf_4
XFILLER_101_691 VGND VGND VPWR VPWR sky130_fd_sc_hd__fill_1
XFILLER_74_586 VGND VGND VPWR VPWR sky130_fd_sc_hd__fill_2
XFILLER_61_214 VGND VGND VPWR VPWR sky130_fd_sc_hd__decap_8
XFILLER_15_653 VPWR VGND VPWR VGND sky130_ef_sc_hd__decap_12
XFILLER_36_93 VPWR VGND VPWR VGND sky130_ef_sc_hd__decap_12
XFILLER_14_141 VGND VGND VPWR VPWR sky130_fd_sc_hd__fill_2
XFILLER_30_645 VPWR VGND VPWR VGND sky130_ef_sc_hd__decap_12
Xinput13 a[20] VGND VGND VPWR VPWR net13 sky130_fd_sc_hd__clkbuf_2
Xinput35 b[11] VGND VGND VPWR VPWR net35 sky130_fd_sc_hd__buf_1
Xinput46 b[21] VGND VGND VPWR VPWR net46 sky130_fd_sc_hd__clkbuf_1
Xinput24 a[30] VGND VGND VPWR VPWR net24 sky130_fd_sc_hd__buf_4
XTAP_TAPCELL_ROW_116_1639 VGND VPWR sky130_fd_sc_hd__tapvpwrvgnd_1
Xinput68 opcode[2] VGND VGND VPWR VPWR net68 sky130_fd_sc_hd__buf_1
Xinput57 b[31] VGND VGND VPWR VPWR net57 sky130_fd_sc_hd__buf_1
XTAP_TAPCELL_ROW_12_397 VGND VPWR sky130_fd_sc_hd__tapvpwrvgnd_1
XFILLER_6_340 VGND VGND VPWR VPWR sky130_fd_sc_hd__fill_1
XFILLER_6_373 VPWR VGND VPWR VGND sky130_ef_sc_hd__decap_12
X_3460_ net351 net441 VGND VGND VPWR VPWR _1364_ sky130_fd_sc_hd__nand2_1
X_5130_ _0896_ _0897_ _0898_ VGND VGND VPWR VPWR _0899_ sky130_fd_sc_hd__and3_1
XFILLER_35_3 VPWR VGND VPWR VGND sky130_ef_sc_hd__decap_12
XFILLER_96_122 VPWR VGND VPWR VGND sky130_ef_sc_hd__decap_12
X_5061_ _0726_ _0823_ VGND VGND VPWR VPWR _0824_ sky130_fd_sc_hd__or2_1
XFILLER_111_477 VPWR VGND VPWR VGND sky130_ef_sc_hd__decap_12
XFILLER_84_317 VGND VGND VPWR VPWR sky130_fd_sc_hd__fill_2
X_4012_ net448 net274 VGND VGND VPWR VPWR _3199_ sky130_fd_sc_hd__nand2_1
XFILLER_65_553 VGND VGND VPWR VPWR sky130_fd_sc_hd__decap_6
XFILLER_92_383 VGND VGND VPWR VPWR sky130_fd_sc_hd__decap_4
XFILLER_65_586 VGND VGND VPWR VPWR sky130_fd_sc_hd__fill_1
X_5963_ _1806_ _1807_ VGND VGND VPWR VPWR _1808_ sky130_fd_sc_hd__and2_1
X_4914_ _0670_ _0671_ _0661_ VGND VGND VPWR VPWR _0673_ sky130_fd_sc_hd__a21oi_1
XFILLER_80_567 VGND VGND VPWR VPWR sky130_fd_sc_hd__decap_3
X_5894_ _1588_ _1731_ VGND VGND VPWR VPWR _1732_ sky130_fd_sc_hd__and2_1
XFILLER_21_601 VPWR VGND VPWR VGND sky130_ef_sc_hd__decap_12
XFILLER_33_461 VPWR VGND VPWR VGND sky130_ef_sc_hd__decap_12
X_4845_ _0602_ _0603_ net114 VGND VGND VPWR VPWR _0605_ sky130_fd_sc_hd__or3b_1
XFILLER_32_29 VPWR VGND VPWR VGND sky130_ef_sc_hd__decap_12
X_4776_ _0464_ _0467_ _0535_ _0536_ VGND VGND VPWR VPWR _0537_ sky130_fd_sc_hd__a211oi_1
X_3727_ _2921_ _2923_ net141 VGND VGND VPWR VPWR _2927_ sky130_fd_sc_hd__a21oi_1
X_6515_ _2404_ _2409_ VGND VGND VPWR VPWR _2410_ sky130_fd_sc_hd__nand2b_1
X_3658_ net408 net416 net423 net456 net349 net280 VGND VGND VPWR VPWR _2861_ sky130_fd_sc_hd__mux4_1
X_6446_ net468 net54 VGND VGND VPWR VPWR _2334_ sky130_fd_sc_hd__nand2_1
XFILLER_88_601 VPWR VGND VPWR VGND sky130_ef_sc_hd__decap_12
X_3589_ net131 _2739_ _2761_ _2706_ VGND VGND VPWR VPWR _2772_ sky130_fd_sc_hd__a211o_1
X_6377_ _2256_ _2257_ _2099_ _2101_ VGND VGND VPWR VPWR _2260_ sky130_fd_sc_hd__a211o_1
X_5328_ _1101_ _1112_ VGND VGND VPWR VPWR _1115_ sky130_fd_sc_hd__xnor2_1
XFILLER_0_505 VPWR VGND VPWR VGND sky130_ef_sc_hd__decap_12
XFILLER_88_645 VPWR VGND VPWR VGND sky130_ef_sc_hd__decap_12
XFILLER_57_15 VPWR VGND VPWR VGND sky130_ef_sc_hd__decap_12
XFILLER_102_488 VGND VGND VPWR VPWR sky130_fd_sc_hd__fill_2
XFILLER_102_477 VGND VGND VPWR VPWR sky130_fd_sc_hd__decap_4
XFILLER_88_689 VGND VGND VPWR VPWR sky130_fd_sc_hd__decap_3
XFILLER_87_155 VGND VGND VPWR VPWR sky130_fd_sc_hd__fill_1
XFILLER_75_328 VGND VGND VPWR VPWR sky130_fd_sc_hd__fill_2
XFILLER_57_48 VGND VGND VPWR VPWR sky130_fd_sc_hd__decap_3
X_5259_ net469 net453 net300 net294 VGND VGND VPWR VPWR _1040_ sky130_fd_sc_hd__and4_1
XFILLER_87_188 VGND VGND VPWR VPWR sky130_fd_sc_hd__decap_6
XFILLER_56_531 VGND VGND VPWR VPWR sky130_fd_sc_hd__fill_1
XFILLER_90_309 VPWR VGND VPWR VGND sky130_ef_sc_hd__decap_12
XFILLER_71_501 VGND VGND VPWR VPWR sky130_fd_sc_hd__decap_3
XFILLER_43_225 VGND VGND VPWR VPWR sky130_fd_sc_hd__decap_3
XFILLER_73_69 VPWR VGND VPWR VGND sky130_ef_sc_hd__decap_12
XFILLER_71_567 VPWR VGND VPWR VGND sky130_ef_sc_hd__decap_12
XFILLER_12_601 VPWR VGND VPWR VGND sky130_ef_sc_hd__decap_12
XFILLER_12_645 VPWR VGND VPWR VGND sky130_ef_sc_hd__decap_12
XFILLER_12_689 VGND VGND VPWR VPWR sky130_fd_sc_hd__decap_3
XFILLER_78_177 VPWR VGND VPWR VGND sky130_ef_sc_hd__decap_12
XFILLER_39_509 VGND VGND VPWR VPWR sky130_fd_sc_hd__fill_1
Xfanout190 net191 VGND VGND VPWR VPWR net190 sky130_fd_sc_hd__dlymetal6s2s_1
XFILLER_94_637 VGND VGND VPWR VPWR sky130_fd_sc_hd__decap_6
XFILLER_93_125 VPWR VGND VPWR VGND sky130_ef_sc_hd__decap_12
XFILLER_59_391 VGND VGND VPWR VPWR sky130_fd_sc_hd__fill_1
XFILLER_93_169 VPWR VGND VPWR VGND sky130_ef_sc_hd__decap_12
XFILLER_47_81 VGND VGND VPWR VPWR sky130_fd_sc_hd__decap_8
XFILLER_47_586 VPWR VGND VPWR VGND sky130_ef_sc_hd__decap_12
XTAP_TAPCELL_ROW_66_1048 VGND VPWR sky130_fd_sc_hd__tapvpwrvgnd_1
XFILLER_62_589 VPWR VGND VPWR VGND sky130_ef_sc_hd__decap_12
XFILLER_62_578 VGND VGND VPWR VPWR sky130_fd_sc_hd__fill_1
XFILLER_15_461 VPWR VGND VPWR VGND sky130_ef_sc_hd__decap_12
XTAP_TAPCELL_ROW_17_456 VGND VPWR sky130_fd_sc_hd__tapvpwrvgnd_1
XTAP_TAPCELL_ROW_45_787 VGND VPWR sky130_fd_sc_hd__tapvpwrvgnd_1
XFILLER_42_291 VGND VGND VPWR VPWR sky130_fd_sc_hd__fill_1
X_4630_ _0327_ _0389_ _0391_ VGND VGND VPWR VPWR _0393_ sky130_fd_sc_hd__nand3_1
XFILLER_30_464 VGND VGND VPWR VPWR sky130_fd_sc_hd__fill_2
XFILLER_8_53 VPWR VGND VPWR VGND sky130_ef_sc_hd__decap_12
X_4561_ _0295_ _0323_ _0324_ VGND VGND VPWR VPWR _0325_ sky130_fd_sc_hd__nand3_1
X_6300_ net451 net253 net53 net468 VGND VGND VPWR VPWR _2175_ sky130_fd_sc_hd__a22oi_1
XFILLER_8_97 VGND VGND VPWR VPWR sky130_fd_sc_hd__fill_1
X_4492_ net415 net208 net201 net423 VGND VGND VPWR VPWR _0257_ sky130_fd_sc_hd__a22o_1
X_3512_ _1168_ _1898_ VGND VGND VPWR VPWR _1931_ sky130_fd_sc_hd__or2_1
XFILLER_7_671 VGND VGND VPWR VPWR sky130_fd_sc_hd__fill_1
XFILLER_116_569 VGND VGND VPWR VPWR sky130_fd_sc_hd__decap_3
XFILLER_89_409 VGND VGND VPWR VPWR sky130_fd_sc_hd__fill_2
XTAP_TAPCELL_ROW_77_1177 VGND VPWR sky130_fd_sc_hd__tapvpwrvgnd_1
X_3443_ _1157_ _1168_ VGND VGND VPWR VPWR _1179_ sky130_fd_sc_hd__or2_1
X_6231_ _2096_ _2097_ _2098_ VGND VGND VPWR VPWR _2100_ sky130_fd_sc_hd__a21oi_1
XTAP_TAPCELL_ROW_90_1333 VGND VPWR sky130_fd_sc_hd__tapvpwrvgnd_1
X_6162_ _2022_ _2023_ VGND VGND VPWR VPWR _2024_ sky130_fd_sc_hd__nor2_1
X_5113_ _0878_ _0879_ _0777_ _0779_ VGND VGND VPWR VPWR _0881_ sky130_fd_sc_hd__a211oi_1
XFILLER_85_615 VGND VGND VPWR VPWR sky130_fd_sc_hd__fill_1
XFILLER_69_166 VGND VGND VPWR VPWR sky130_fd_sc_hd__fill_2
X_6093_ net235 net223 net443 net441 VGND VGND VPWR VPWR _1949_ sky130_fd_sc_hd__and4_1
X_5044_ _0716_ _0718_ _0717_ VGND VGND VPWR VPWR _0805_ sky130_fd_sc_hd__a21bo_1
XFILLER_69_199 VGND VGND VPWR VPWR sky130_fd_sc_hd__decap_8
XFILLER_72_309 VGND VGND VPWR VPWR sky130_fd_sc_hd__decap_8
XFILLER_38_586 VGND VGND VPWR VPWR sky130_fd_sc_hd__fill_2
XFILLER_25_225 VGND VGND VPWR VPWR sky130_fd_sc_hd__decap_4
X_5946_ _1785_ _1787_ _1772_ VGND VGND VPWR VPWR _1789_ sky130_fd_sc_hd__o21ai_1
XFILLER_40_217 VGND VGND VPWR VPWR sky130_fd_sc_hd__fill_1
X_5877_ _1586_ _1713_ VGND VGND VPWR VPWR _1715_ sky130_fd_sc_hd__or2_1
XFILLER_21_420 VGND VGND VPWR VPWR sky130_fd_sc_hd__fill_2
X_4828_ _0586_ _0587_ _0580_ VGND VGND VPWR VPWR _0588_ sky130_fd_sc_hd__a21o_1
XFILLER_21_497 VGND VGND VPWR VPWR sky130_fd_sc_hd__decap_6
X_4759_ _0435_ _0447_ _0446_ VGND VGND VPWR VPWR _0520_ sky130_fd_sc_hd__a21bo_1
XFILLER_107_514 VPWR VGND VPWR VGND sky130_ef_sc_hd__decap_12
XFILLER_4_118 VGND VGND VPWR VPWR sky130_fd_sc_hd__decap_4
XFILLER_107_558 VGND VGND VPWR VPWR sky130_fd_sc_hd__fill_2
X_6429_ _2312_ _2315_ _2153_ _2155_ VGND VGND VPWR VPWR _2317_ sky130_fd_sc_hd__o211ai_2
XFILLER_108_65 VGND VGND VPWR VPWR sky130_fd_sc_hd__fill_2
XFILLER_88_431 VPWR VGND VPWR VGND sky130_ef_sc_hd__decap_12
XFILLER_88_475 VGND VGND VPWR VPWR sky130_fd_sc_hd__fill_1
XFILLER_48_339 VGND VGND VPWR VPWR sky130_fd_sc_hd__fill_1
XFILLER_75_169 VGND VGND VPWR VPWR sky130_fd_sc_hd__decap_6
XFILLER_56_350 VGND VGND VPWR VPWR sky130_fd_sc_hd__fill_2
XFILLER_91_629 VPWR VGND VPWR VGND sky130_ef_sc_hd__decap_12
XFILLER_90_128 VPWR VGND VPWR VGND sky130_ef_sc_hd__decap_12
XFILLER_84_681 VGND VGND VPWR VPWR sky130_fd_sc_hd__decap_8
XFILLER_44_512 VGND VGND VPWR VPWR sky130_fd_sc_hd__decap_8
XFILLER_17_51 VGND VGND VPWR VPWR sky130_fd_sc_hd__decap_4
XFILLER_44_545 VPWR VGND VPWR VGND sky130_ef_sc_hd__decap_12
XTAP_TAPCELL_ROW_14_415 VGND VPWR sky130_fd_sc_hd__tapvpwrvgnd_1
XTAP_TAPCELL_ROW_42_757 VGND VPWR sky130_fd_sc_hd__tapvpwrvgnd_1
XFILLER_12_475 VGND VGND VPWR VPWR sky130_fd_sc_hd__fill_1
XFILLER_8_457 VPWR VGND VPWR VGND sky130_ef_sc_hd__decap_12
XTAP_TAPCELL_ROW_113_1609 VGND VPWR sky130_fd_sc_hd__tapvpwrvgnd_1
XFILLER_113_517 VPWR VGND VPWR VGND sky130_ef_sc_hd__decap_12
XFILLER_98_228 VGND VGND VPWR VPWR sky130_fd_sc_hd__fill_1
XFILLER_3_173 VGND VGND VPWR VPWR sky130_fd_sc_hd__fill_1
XFILLER_94_467 VGND VGND VPWR VPWR sky130_fd_sc_hd__decap_8
XFILLER_54_309 VGND VGND VPWR VPWR sky130_fd_sc_hd__fill_1
XFILLER_35_501 VGND VGND VPWR VPWR sky130_fd_sc_hd__decap_3
XFILLER_35_545 VPWR VGND VPWR VGND sky130_ef_sc_hd__decap_12
X_5800_ _1502_ _1504_ VGND VGND VPWR VPWR _1630_ sky130_fd_sc_hd__nand2_1
X_6780_ _2694_ _2698_ VGND VGND VPWR VPWR _2699_ sky130_fd_sc_hd__xnor2_1
X_3992_ net298 net465 VGND VGND VPWR VPWR _3180_ sky130_fd_sc_hd__nand2b_1
X_5731_ _1543_ _1553_ _1554_ VGND VGND VPWR VPWR _1555_ sky130_fd_sc_hd__and3_2
X_5662_ _1384_ _1392_ _1477_ VGND VGND VPWR VPWR _1479_ sky130_fd_sc_hd__and3_1
X_4613_ net393 net215 _0373_ _0374_ VGND VGND VPWR VPWR _0376_ sky130_fd_sc_hd__nand4_1
XFILLER_30_283 VPWR VGND VPWR VGND sky130_ef_sc_hd__decap_12
X_5593_ net361 net429 net331 net325 VGND VGND VPWR VPWR _1404_ sky130_fd_sc_hd__nand4_1
X_4544_ _0296_ _0306_ _0307_ VGND VGND VPWR VPWR _0308_ sky130_fd_sc_hd__nand3_2
Xmax_cap110 _1704_ VGND VGND VPWR VPWR net110 sky130_fd_sc_hd__buf_1
XFILLER_116_333 VGND VGND VPWR VPWR sky130_fd_sc_hd__decap_3
X_4475_ net239 net226 net399 net391 VGND VGND VPWR VPWR _0240_ sky130_fd_sc_hd__nand4_1
X_6214_ _2078_ _2079_ VGND VGND VPWR VPWR _2081_ sky130_fd_sc_hd__xor2_1
X_3426_ net265 VGND VGND VPWR VPWR _0994_ sky130_fd_sc_hd__inv_2
X_6145_ _2003_ _2004_ _1848_ _1851_ VGND VGND VPWR VPWR _2006_ sky130_fd_sc_hd__a211o_1
X_6076_ _1927_ _1928_ _1919_ VGND VGND VPWR VPWR _1930_ sky130_fd_sc_hd__a21o_1
X_5027_ _0784_ _0785_ _0786_ VGND VGND VPWR VPWR _0788_ sky130_fd_sc_hd__and3_1
XFILLER_85_478 VGND VGND VPWR VPWR sky130_fd_sc_hd__fill_1
XFILLER_72_106 VGND VGND VPWR VPWR sky130_fd_sc_hd__decap_8
XFILLER_66_681 VGND VGND VPWR VPWR sky130_fd_sc_hd__decap_8
XFILLER_72_139 VGND VGND VPWR VPWR sky130_fd_sc_hd__fill_1
XFILLER_26_545 VPWR VGND VPWR VGND sky130_ef_sc_hd__decap_12
XFILLER_81_673 VPWR VGND VPWR VGND sky130_ef_sc_hd__decap_12
XFILLER_80_161 VPWR VGND VPWR VGND sky130_ef_sc_hd__decap_12
XFILLER_26_589 VPWR VGND VPWR VGND sky130_ef_sc_hd__decap_12
XFILLER_80_194 VGND VGND VPWR VPWR sky130_fd_sc_hd__fill_2
XFILLER_41_537 VGND VGND VPWR VPWR sky130_fd_sc_hd__decap_4
XFILLER_41_548 VGND VGND VPWR VPWR sky130_fd_sc_hd__decap_6
XFILLER_110_77 VGND VGND VPWR VPWR sky130_fd_sc_hd__decap_6
XFILLER_70_26 VGND VGND VPWR VPWR sky130_fd_sc_hd__fill_2
X_5929_ _1769_ _1770_ VGND VGND VPWR VPWR _1771_ sky130_fd_sc_hd__xnor2_1
XFILLER_5_449 VPWR VGND VPWR VGND sky130_ef_sc_hd__decap_12
XFILLER_102_3 VPWR VGND VPWR VGND sky130_ef_sc_hd__decap_12
XFILLER_79_57 VPWR VGND VPWR VGND sky130_ef_sc_hd__decap_12
XFILLER_103_561 VPWR VGND VPWR VGND sky130_ef_sc_hd__decap_12
XFILLER_76_445 VGND VGND VPWR VPWR sky130_fd_sc_hd__decap_6
XFILLER_36_309 VGND VGND VPWR VPWR sky130_fd_sc_hd__fill_1
XFILLER_48_147 VPWR VGND VPWR VGND sky130_ef_sc_hd__decap_12
XFILLER_28_83 VGND VGND VPWR VPWR sky130_fd_sc_hd__fill_1
XTAP_TAPCELL_ROW_47_816 VGND VPWR sky130_fd_sc_hd__tapvpwrvgnd_1
XFILLER_17_556 VGND VGND VPWR VPWR sky130_fd_sc_hd__decap_4
XFILLER_71_150 VGND VGND VPWR VPWR sky130_fd_sc_hd__decap_6
XTAP_TAPCELL_ROW_63_1007 VGND VPWR sky130_fd_sc_hd__tapvpwrvgnd_1
XFILLER_32_504 VPWR VGND VPWR VGND sky130_ef_sc_hd__decap_12
XFILLER_71_172 VPWR VGND VPWR VGND sky130_ef_sc_hd__decap_12
XTAP_TAPCELL_ROW_27_573 VGND VPWR sky130_fd_sc_hd__tapvpwrvgnd_1
XTAP_TAPCELL_ROW_74_1136 VGND VPWR sky130_fd_sc_hd__tapvpwrvgnd_1
XFILLER_99_559 VGND VGND VPWR VPWR sky130_fd_sc_hd__fill_1
X_4260_ _0033_ _0034_ _0031_ VGND VGND VPWR VPWR _0035_ sky130_fd_sc_hd__mux2_1
XFILLER_86_209 VGND VGND VPWR VPWR sky130_fd_sc_hd__decap_4
XFILLER_67_401 VGND VGND VPWR VPWR sky130_fd_sc_hd__fill_2
X_4191_ net427 net53 VGND VGND VPWR VPWR _3370_ sky130_fd_sc_hd__and2_1
XFILLER_55_607 VGND VGND VPWR VPWR sky130_fd_sc_hd__decap_8
XFILLER_55_629 VPWR VGND VPWR VGND sky130_ef_sc_hd__decap_12
XFILLER_39_169 VPWR VGND VPWR VGND sky130_ef_sc_hd__decap_12
XFILLER_48_681 VGND VGND VPWR VPWR sky130_fd_sc_hd__decap_8
XFILLER_82_459 VGND VGND VPWR VPWR sky130_fd_sc_hd__decap_3
XFILLER_63_640 VPWR VGND VPWR VGND sky130_ef_sc_hd__decap_12
X_6901_ net182 _alu_i0.Datapath_i.fu_alu_33673_33851.out1\[27\] VGND VGND VPWR VPWR
+ _alu_i0.Datapath_i.reg_0.reg_out1\[27\] sky130_fd_sc_hd__dfxtp_1
XFILLER_63_673 VPWR VGND VPWR VGND sky130_ef_sc_hd__decap_12
XFILLER_35_353 VGND VGND VPWR VPWR sky130_fd_sc_hd__decap_3
X_6832_ _2753_ _2755_ VGND VGND VPWR VPWR _2756_ sky130_fd_sc_hd__xnor2_1
XTAP_TAPCELL_ROW_85_1276 VGND VPWR sky130_fd_sc_hd__tapvpwrvgnd_1
XFILLER_62_183 VGND VGND VPWR VPWR sky130_fd_sc_hd__fill_1
XFILLER_35_386 VGND VGND VPWR VPWR sky130_fd_sc_hd__fill_2
XFILLER_23_559 VGND VGND VPWR VPWR sky130_fd_sc_hd__fill_1
X_6763_ _2678_ _2679_ VGND VGND VPWR VPWR _2680_ sky130_fd_sc_hd__nand2b_1
X_3975_ _3163_ VGND VGND VPWR VPWR _3164_ sky130_fd_sc_hd__inv_2
X_6694_ net245 net427 VGND VGND VPWR VPWR _2605_ sky130_fd_sc_hd__nand2_1
X_5714_ net283 net443 VGND VGND VPWR VPWR _1536_ sky130_fd_sc_hd__and2_1
XFILLER_109_609 VGND VGND VPWR VPWR sky130_fd_sc_hd__decap_6
X_5645_ _1459_ _1460_ _alu_i0.Datapath_i.reg_0.reg_out1\[22\] net149 VGND VGND VPWR
+ VPWR net91 sky130_fd_sc_hd__a2bb2o_1
XFILLER_40_29 VPWR VGND VPWR VGND sky130_ef_sc_hd__decap_12
X_5576_ _1261_ _1383_ VGND VGND VPWR VPWR _1385_ sky130_fd_sc_hd__xnor2_1
XFILLER_116_141 VGND VGND VPWR VPWR sky130_fd_sc_hd__decap_8
X_4527_ net474 net457 net191 net345 VGND VGND VPWR VPWR _0291_ sky130_fd_sc_hd__and4_1
X_4458_ _0177_ _0222_ _0223_ VGND VGND VPWR VPWR _0224_ sky130_fd_sc_hd__nor3_2
X_3409_ net222 VGND VGND VPWR VPWR _0808_ sky130_fd_sc_hd__inv_2
X_4389_ _0152_ _0155_ VGND VGND VPWR VPWR _0156_ sky130_fd_sc_hd__xnor2_1
XFILLER_100_520 VPWR VGND VPWR VGND sky130_ef_sc_hd__decap_12
XFILLER_98_581 VGND VGND VPWR VPWR sky130_fd_sc_hd__decap_6
XFILLER_58_401 VGND VGND VPWR VPWR sky130_fd_sc_hd__decap_4
X_6128_ _1984_ _1985_ _1831_ _1833_ VGND VGND VPWR VPWR _1988_ sky130_fd_sc_hd__a211o_1
XFILLER_105_55 VGND VGND VPWR VPWR sky130_fd_sc_hd__fill_1
XFILLER_85_242 VPWR VGND VPWR VGND sky130_ef_sc_hd__decap_12
XFILLER_58_445 VPWR VGND VPWR VGND sky130_ef_sc_hd__decap_12
XFILLER_73_426 VGND VGND VPWR VPWR sky130_fd_sc_hd__decap_4
XFILLER_73_404 VPWR VGND VPWR VGND sky130_ef_sc_hd__decap_12
XFILLER_58_489 VGND VGND VPWR VPWR sky130_fd_sc_hd__decap_6
XFILLER_18_309 VGND VGND VPWR VPWR sky130_fd_sc_hd__decap_8
X_6059_ net174 net336 _1908_ _1911_ VGND VGND VPWR VPWR _1912_ sky130_fd_sc_hd__nand4_1
XFILLER_60_109 VGND VGND VPWR VPWR sky130_fd_sc_hd__decap_4
XFILLER_53_161 VGND VGND VPWR VPWR sky130_fd_sc_hd__decap_6
XTAP_TAPCELL_ROW_24_543 VGND VPWR sky130_fd_sc_hd__tapvpwrvgnd_1
XFILLER_14_41 VPWR VGND VPWR VGND sky130_ef_sc_hd__decap_12
XTAP_TAPCELL_ROW_52_874 VGND VPWR sky130_fd_sc_hd__tapvpwrvgnd_1
XFILLER_14_85 VGND VGND VPWR VPWR sky130_fd_sc_hd__decap_8
XFILLER_22_581 VGND VGND VPWR VPWR sky130_fd_sc_hd__decap_6
XFILLER_5_246 VGND VGND VPWR VPWR sky130_fd_sc_hd__fill_1
XFILLER_103_391 VGND VGND VPWR VPWR sky130_fd_sc_hd__fill_1
XFILLER_39_71 VPWR VGND VPWR VGND sky130_ef_sc_hd__decap_12
XFILLER_91_201 VPWR VGND VPWR VGND sky130_ef_sc_hd__decap_12
XFILLER_37_629 VPWR VGND VPWR VGND sky130_ef_sc_hd__decap_12
XFILLER_17_353 VGND VGND VPWR VPWR sky130_fd_sc_hd__decap_3
XFILLER_45_673 VPWR VGND VPWR VGND sky130_ef_sc_hd__decap_12
XFILLER_60_632 VPWR VGND VPWR VGND sky130_ef_sc_hd__decap_12
XFILLER_32_345 VGND VGND VPWR VPWR sky130_fd_sc_hd__fill_1
X_3760_ net231 _1277_ VGND VGND VPWR VPWR _2959_ sky130_fd_sc_hd__nor2_2
X_3691_ _1714_ _2890_ _2892_ VGND VGND VPWR VPWR _alu_i0.Datapath_i.fu_alu_33673_33851.out1\[5\]
+ sky130_fd_sc_hd__a21o_1
X_5430_ _1103_ _1111_ _1110_ VGND VGND VPWR VPWR _1226_ sky130_fd_sc_hd__a21oi_1
XFILLER_9_585 VPWR VGND VPWR VGND sky130_ef_sc_hd__decap_12
XFILLER_114_601 VPWR VGND VPWR VGND sky130_ef_sc_hd__decap_12
X_5361_ _1144_ _1150_ VGND VGND VPWR VPWR _1151_ sky130_fd_sc_hd__nand2b_1
XFILLER_114_645 VPWR VGND VPWR VGND sky130_ef_sc_hd__decap_12
XFILLER_113_111 VGND VGND VPWR VPWR sky130_fd_sc_hd__fill_1
X_4312_ _0060_ _0081_ VGND VGND VPWR VPWR _0082_ sky130_fd_sc_hd__and2_1
X_5292_ _1073_ _1074_ _0966_ _0968_ VGND VGND VPWR VPWR _1076_ sky130_fd_sc_hd__a211oi_1
XFILLER_114_689 VGND VGND VPWR VPWR sky130_fd_sc_hd__decap_3
X_4243_ net144 _0018_ VGND VGND VPWR VPWR _0019_ sky130_fd_sc_hd__nand2_1
X_4174_ _3331_ _3339_ _3353_ VGND VGND VPWR VPWR _3354_ sky130_fd_sc_hd__a21oi_1
XFILLER_95_573 VPWR VGND VPWR VGND sky130_ef_sc_hd__decap_12
XFILLER_67_286 VGND VGND VPWR VPWR sky130_fd_sc_hd__decap_6
X_6815_ _2512_ _2736_ VGND VGND VPWR VPWR _2737_ sky130_fd_sc_hd__xor2_1
XFILLER_23_356 VPWR VGND VPWR VGND sky130_ef_sc_hd__decap_12
XFILLER_51_665 VGND VGND VPWR VPWR sky130_fd_sc_hd__decap_6
XFILLER_11_529 VPWR VGND VPWR VGND sky130_ef_sc_hd__decap_12
XTAP_TAPCELL_ROW_21_502 VGND VPWR sky130_fd_sc_hd__tapvpwrvgnd_1
X_6746_ _2326_ _2489_ _2490_ VGND VGND VPWR VPWR _2662_ sky130_fd_sc_hd__o21ba_1
XFILLER_50_153 VPWR VGND VPWR VGND sky130_ef_sc_hd__decap_12
XFILLER_50_197 VGND VGND VPWR VPWR sky130_fd_sc_hd__decap_4
X_3958_ net143 _3142_ _3146_ _3147_ VGND VGND VPWR VPWR _3148_ sky130_fd_sc_hd__o22a_1
XTAP_TAPCELL_ROW_98_1423 VGND VPWR sky130_fd_sc_hd__tapvpwrvgnd_1
X_3889_ _3058_ _3075_ _3080_ VGND VGND VPWR VPWR _3082_ sky130_fd_sc_hd__or3_1
X_6677_ _2410_ _2414_ _2585_ VGND VGND VPWR VPWR _2587_ sky130_fd_sc_hd__a21oi_1
X_5628_ _1439_ _1440_ _1316_ _1318_ VGND VGND VPWR VPWR _1443_ sky130_fd_sc_hd__o211ai_2
X_5559_ _1366_ VGND VGND VPWR VPWR _1367_ sky130_fd_sc_hd__inv_2
XFILLER_2_216 VGND VGND VPWR VPWR sky130_fd_sc_hd__decap_3
XFILLER_2_238 VPWR VGND VPWR VGND sky130_ef_sc_hd__decap_12
XFILLER_58_242 VGND VGND VPWR VPWR sky130_fd_sc_hd__fill_2
XFILLER_86_562 VGND VGND VPWR VPWR sky130_fd_sc_hd__fill_1
XFILLER_76_69 VPWR VGND VPWR VGND sky130_ef_sc_hd__decap_12
XFILLER_58_253 VGND VGND VPWR VPWR sky130_fd_sc_hd__decap_3
XFILLER_19_629 VPWR VGND VPWR VGND sky130_ef_sc_hd__decap_12
XTAP_TAPCELL_ROW_29_602 VGND VPWR sky130_fd_sc_hd__tapvpwrvgnd_1
XFILLER_100_394 VPWR VGND VPWR VGND sky130_ef_sc_hd__decap_12
XFILLER_73_234 VGND VGND VPWR VPWR sky130_fd_sc_hd__decap_4
XFILLER_58_297 VGND VGND VPWR VPWR sky130_fd_sc_hd__decap_8
XTAP_TAPCELL_ROW_57_933 VGND VPWR sky130_fd_sc_hd__tapvpwrvgnd_1
XTAP_TAPCELL_ROW_107_1541 VGND VPWR sky130_fd_sc_hd__tapvpwrvgnd_1
XTAP_TAPCELL_ROW_107_1530 VGND VPWR sky130_fd_sc_hd__tapvpwrvgnd_1
XTAP_TAPCELL_ROW_1_260 VGND VPWR sky130_fd_sc_hd__tapvpwrvgnd_1
XFILLER_61_429 VGND VGND VPWR VPWR sky130_fd_sc_hd__decap_3
XFILLER_27_673 VPWR VGND VPWR VGND sky130_ef_sc_hd__decap_12
XPHY_EDGE_ROW_1_Left_118 VGND VGND VPWR VPWR sky130_fd_sc_hd__decap_3
XFILLER_25_51 VGND VGND VPWR VPWR sky130_fd_sc_hd__decap_4
XFILLER_26_194 VGND VGND VPWR VPWR sky130_fd_sc_hd__fill_2
XTAP_TAPCELL_ROW_37_690 VGND VPWR sky130_fd_sc_hd__tapvpwrvgnd_1
XFILLER_41_131 VPWR VGND VPWR VGND sky130_ef_sc_hd__decap_12
XFILLER_42_632 VPWR VGND VPWR VGND sky130_ef_sc_hd__decap_12
XFILLER_6_533 VPWR VGND VPWR VGND sky130_ef_sc_hd__decap_12
XFILLER_108_450 VGND VGND VPWR VPWR sky130_fd_sc_hd__decap_8
XFILLER_51_9 VPWR VGND VPWR VGND sky130_ef_sc_hd__decap_12
XTAP_TAPCELL_ROW_71_1106 VGND VPWR sky130_fd_sc_hd__tapvpwrvgnd_1
XTAP_TAPCELL_ROW_9_360 VGND VPWR sky130_fd_sc_hd__tapvpwrvgnd_1
XFILLER_111_615 VGND VGND VPWR VPWR sky130_fd_sc_hd__fill_1
XFILLER_2_77 VGND VGND VPWR VPWR sky130_fd_sc_hd__decap_6
XTAP_TAPCELL_ROW_69_1079 VGND VPWR sky130_fd_sc_hd__tapvpwrvgnd_1
X_4930_ _0686_ _0687_ _0600_ VGND VGND VPWR VPWR _0689_ sky130_fd_sc_hd__a21bo_1
XFILLER_17_150 VPWR VGND VPWR VGND sky130_ef_sc_hd__decap_12
XFILLER_24_109 VGND VGND VPWR VPWR sky130_fd_sc_hd__decap_6
X_4861_ _0615_ _0617_ _0619_ net147 VGND VGND VPWR VPWR _0621_ sky130_fd_sc_hd__o31ai_1
XTAP_TAPCELL_ROW_82_1235 VGND VPWR sky130_fd_sc_hd__tapvpwrvgnd_1
XFILLER_33_665 VGND VGND VPWR VPWR sky130_fd_sc_hd__decap_6
X_3812_ _2990_ _3007_ VGND VGND VPWR VPWR _3008_ sky130_fd_sc_hd__nand2_1
X_6600_ _2334_ _2501_ VGND VGND VPWR VPWR _2502_ sky130_fd_sc_hd__or2_1
X_4792_ _0550_ _0551_ _0549_ VGND VGND VPWR VPWR _0552_ sky130_fd_sc_hd__a21o_1
XANTENNA_16 net28 VGND VGND VPWR VPWR sky130_fd_sc_hd__diode_2
XANTENNA_27 net328 VGND VGND VPWR VPWR sky130_fd_sc_hd__diode_2
XANTENNA_38 net382 VGND VGND VPWR VPWR sky130_fd_sc_hd__diode_2
XFILLER_20_348 VGND VGND VPWR VPWR sky130_fd_sc_hd__decap_8
XFILLER_32_197 VPWR VGND VPWR VGND sky130_ef_sc_hd__decap_12
X_3743_ net372 net194 VGND VGND VPWR VPWR _2942_ sky130_fd_sc_hd__and2_2
X_6531_ _2222_ _2261_ _2426_ _2427_ VGND VGND VPWR VPWR _2428_ sky130_fd_sc_hd__o211ai_2
X_3674_ _2872_ _2875_ net125 VGND VGND VPWR VPWR _2876_ sky130_fd_sc_hd__o21ai_1
X_6462_ _2350_ _2351_ VGND VGND VPWR VPWR _2352_ sky130_fd_sc_hd__and2_1
XFILLER_9_393 VPWR VGND VPWR VGND sky130_ef_sc_hd__decap_12
X_5413_ _1206_ _1207_ VGND VGND VPWR VPWR _1208_ sky130_fd_sc_hd__xnor2_1
Xoutput101 net101 VGND VGND VPWR VPWR return_port[31] sky130_fd_sc_hd__clkbuf_4
X_6393_ _2119_ _2121_ VGND VGND VPWR VPWR _2277_ sky130_fd_sc_hd__nand2_1
XFILLER_99_120 VGND VGND VPWR VPWR sky130_fd_sc_hd__decap_8
X_5344_ _1021_ _1024_ _1130_ _1131_ VGND VGND VPWR VPWR _1132_ sky130_fd_sc_hd__a211oi_1
XTAP_TAPCELL_ROW_93_1364 VGND VPWR sky130_fd_sc_hd__tapvpwrvgnd_1
XFILLER_114_475 VGND VGND VPWR VPWR sky130_fd_sc_hd__fill_1
XFILLER_102_637 VGND VGND VPWR VPWR sky130_fd_sc_hd__decap_6
X_5275_ _1055_ _1056_ VGND VGND VPWR VPWR _1057_ sky130_fd_sc_hd__and2b_1
XFILLER_101_125 VPWR VGND VPWR VGND sky130_ef_sc_hd__decap_12
XFILLER_87_337 VPWR VGND VPWR VGND sky130_ef_sc_hd__decap_12
X_4226_ _3403_ _3362_ net278 VGND VGND VPWR VPWR _3404_ sky130_fd_sc_hd__mux2_1
XFILLER_101_169 VGND VGND VPWR VPWR sky130_fd_sc_hd__decap_8
XFILLER_68_573 VGND VGND VPWR VPWR sky130_fd_sc_hd__fill_1
X_4157_ _3283_ _3314_ _3313_ VGND VGND VPWR VPWR _3338_ sky130_fd_sc_hd__o21ai_1
XFILLER_110_681 VGND VGND VPWR VPWR sky130_fd_sc_hd__decap_8
XFILLER_83_532 VGND VGND VPWR VPWR sky130_fd_sc_hd__decap_8
XFILLER_83_576 VGND VGND VPWR VPWR sky130_fd_sc_hd__decap_3
XTAP_TAPCELL_ROW_54_903 VGND VPWR sky130_fd_sc_hd__tapvpwrvgnd_1
X_4088_ _3255_ _3267_ net140 VGND VGND VPWR VPWR _3272_ sky130_fd_sc_hd__a21oi_1
XFILLER_70_248 VGND VGND VPWR VPWR sky130_fd_sc_hd__decap_4
XFILLER_70_237 VGND VGND VPWR VPWR sky130_fd_sc_hd__decap_3
XFILLER_62_27 VGND VGND VPWR VPWR sky130_fd_sc_hd__fill_1
XFILLER_24_643 VGND VGND VPWR VPWR sky130_fd_sc_hd__fill_1
XFILLER_62_49 VGND VGND VPWR VPWR sky130_fd_sc_hd__fill_1
XTAP_TAPCELL_ROW_34_660 VGND VPWR sky130_fd_sc_hd__tapvpwrvgnd_1
XTAP_TAPCELL_ROW_102_1471 VGND VPWR sky130_fd_sc_hd__tapvpwrvgnd_1
XTAP_TAPCELL_ROW_62_991 VGND VPWR sky130_fd_sc_hd__tapvpwrvgnd_1
XFILLER_11_315 VPWR VGND VPWR VGND sky130_ef_sc_hd__decap_12
X_6729_ _2600_ _2643_ VGND VGND VPWR VPWR _2644_ sky130_fd_sc_hd__xnor2_1
XFILLER_109_225 VPWR VGND VPWR VGND sky130_ef_sc_hd__decap_12
XFILLER_78_326 VGND VGND VPWR VPWR sky130_fd_sc_hd__decap_4
Xfanout350 net353 VGND VGND VPWR VPWR net350 sky130_fd_sc_hd__clkbuf_4
Xfanout372 net373 VGND VGND VPWR VPWR net372 sky130_fd_sc_hd__clkbuf_4
Xfanout383 net384 VGND VGND VPWR VPWR net383 sky130_fd_sc_hd__clkbuf_4
Xfanout361 net366 VGND VGND VPWR VPWR net361 sky130_fd_sc_hd__clkbuf_4
Xfanout394 net29 VGND VGND VPWR VPWR net394 sky130_fd_sc_hd__clkbuf_4
XFILLER_46_223 VGND VGND VPWR VPWR sky130_fd_sc_hd__fill_1
XFILLER_100_180 VPWR VGND VPWR VGND sky130_ef_sc_hd__decap_12
XFILLER_15_665 VGND VGND VPWR VPWR sky130_fd_sc_hd__decap_6
XFILLER_14_197 VGND VGND VPWR VPWR sky130_fd_sc_hd__decap_8
XFILLER_30_657 VPWR VGND VPWR VGND sky130_ef_sc_hd__decap_12
XFILLER_52_82 VGND VGND VPWR VPWR sky130_fd_sc_hd__fill_2
XFILLER_52_93 VGND VGND VPWR VPWR sky130_fd_sc_hd__fill_1
Xinput36 b[12] VGND VGND VPWR VPWR net36 sky130_fd_sc_hd__clkbuf_2
Xinput25 a[31] VGND VGND VPWR VPWR net25 sky130_fd_sc_hd__dlymetal6s2s_1
Xinput14 a[21] VGND VGND VPWR VPWR net14 sky130_fd_sc_hd__buf_1
Xinput58 b[3] VGND VGND VPWR VPWR net58 sky130_fd_sc_hd__buf_1
Xinput69 opcode[3] VGND VGND VPWR VPWR net69 sky130_fd_sc_hd__clkbuf_1
XTAP_TAPCELL_ROW_12_398 VGND VPWR sky130_fd_sc_hd__tapvpwrvgnd_1
Xinput47 b[22] VGND VGND VPWR VPWR net47 sky130_fd_sc_hd__clkbuf_1
XFILLER_115_217 VGND VGND VPWR VPWR sky130_fd_sc_hd__decap_6
XFILLER_6_385 VGND VGND VPWR VPWR sky130_fd_sc_hd__decap_6
XFILLER_96_134 VGND VGND VPWR VPWR sky130_fd_sc_hd__decap_3
X_5060_ _0810_ _0822_ VGND VGND VPWR VPWR _0823_ sky130_fd_sc_hd__xnor2_1
XFILLER_69_337 VGND VGND VPWR VPWR sky130_fd_sc_hd__decap_6
XFILLER_111_489 VPWR VGND VPWR VGND sky130_ef_sc_hd__decap_12
XFILLER_28_3 VPWR VGND VPWR VGND sky130_ef_sc_hd__decap_12
X_4011_ net448 net274 VGND VGND VPWR VPWR _3198_ sky130_fd_sc_hd__or2_1
XFILLER_37_223 VGND VGND VPWR VPWR sky130_fd_sc_hd__fill_1
XFILLER_92_351 VGND VGND VPWR VPWR sky130_fd_sc_hd__decap_4
XFILLER_92_340 VGND VGND VPWR VPWR sky130_fd_sc_hd__decap_4
XFILLER_25_407 VPWR VGND VPWR VGND sky130_ef_sc_hd__decap_12
XFILLER_92_362 VGND VGND VPWR VPWR sky130_fd_sc_hd__fill_2
X_5962_ net247 net443 _1660_ _1658_ VGND VGND VPWR VPWR _1807_ sky130_fd_sc_hd__a31o_1
X_4913_ _0661_ _0670_ _0671_ VGND VGND VPWR VPWR _0672_ sky130_fd_sc_hd__and3_1
X_5893_ _1729_ _1730_ VGND VGND VPWR VPWR _1731_ sky130_fd_sc_hd__nor2_1
XFILLER_21_613 VGND VGND VPWR VPWR sky130_fd_sc_hd__decap_3
XFILLER_33_473 VPWR VGND VPWR VGND sky130_ef_sc_hd__decap_12
X_4844_ _0602_ _0603_ net114 VGND VGND VPWR VPWR _0604_ sky130_fd_sc_hd__nor3b_1
XFILLER_33_495 VGND VGND VPWR VPWR sky130_fd_sc_hd__decap_8
X_4775_ _0533_ _0534_ _0431_ _0433_ VGND VGND VPWR VPWR _0536_ sky130_fd_sc_hd__o211a_1
X_3726_ _2920_ _2924_ VGND VGND VPWR VPWR _2926_ sky130_fd_sc_hd__nand2_1
X_6514_ _2407_ _2408_ VGND VGND VPWR VPWR _2409_ sky130_fd_sc_hd__xnor2_1
X_3657_ _2858_ _2859_ net154 VGND VGND VPWR VPWR _2860_ sky130_fd_sc_hd__mux2_1
X_6445_ _alu_i0.Datapath_i.reg_0.reg_out1\[28\] _2333_ net147 VGND VGND VPWR VPWR
+ net97 sky130_fd_sc_hd__mux2_1
X_3588_ _1266_ _2564_ _2750_ net118 VGND VGND VPWR VPWR _2761_ sky130_fd_sc_hd__a22o_1
X_6376_ _2099_ _2101_ _2256_ _2257_ VGND VGND VPWR VPWR _2258_ sky130_fd_sc_hd__o211ai_2
XFILLER_88_613 VPWR VGND VPWR VGND sky130_ef_sc_hd__decap_12
XFILLER_87_101 VGND VGND VPWR VPWR sky130_fd_sc_hd__decap_8
X_5327_ _1101_ _1112_ VGND VGND VPWR VPWR _1114_ sky130_fd_sc_hd__and2b_1
XFILLER_0_517 VPWR VGND VPWR VGND sky130_ef_sc_hd__decap_12
XFILLER_114_294 VGND VGND VPWR VPWR sky130_fd_sc_hd__fill_1
XFILLER_102_434 VGND VGND VPWR VPWR sky130_fd_sc_hd__decap_4
XFILLER_88_657 VPWR VGND VPWR VGND sky130_ef_sc_hd__decap_12
XFILLER_87_123 VPWR VGND VPWR VGND sky130_ef_sc_hd__decap_12
XFILLER_87_167 VGND VGND VPWR VPWR sky130_fd_sc_hd__fill_1
XFILLER_57_27 VGND VGND VPWR VPWR sky130_fd_sc_hd__decap_6
X_5258_ net421 net303 VGND VGND VPWR VPWR _1039_ sky130_fd_sc_hd__nand2_1
X_5189_ _0811_ _0815_ _0962_ VGND VGND VPWR VPWR _0964_ sky130_fd_sc_hd__nor3_1
X_4209_ net154 _3220_ _3387_ net122 VGND VGND VPWR VPWR _3388_ sky130_fd_sc_hd__o211a_1
XFILLER_113_55 VGND VGND VPWR VPWR sky130_fd_sc_hd__fill_1
XTAP_TAPCELL_ROW_104_1500 VGND VPWR sky130_fd_sc_hd__tapvpwrvgnd_1
XFILLER_71_535 VGND VGND VPWR VPWR sky130_fd_sc_hd__fill_1
XFILLER_71_579 VPWR VGND VPWR VGND sky130_ef_sc_hd__decap_12
XFILLER_12_613 VPWR VGND VPWR VGND sky130_ef_sc_hd__decap_12
XFILLER_51_281 VGND VGND VPWR VPWR sky130_fd_sc_hd__fill_1
XPHY_EDGE_ROW_91_Left_208 VGND VGND VPWR VPWR sky130_fd_sc_hd__decap_3
XFILLER_12_657 VPWR VGND VPWR VGND sky130_ef_sc_hd__decap_12
XFILLER_11_167 VGND VGND VPWR VPWR sky130_fd_sc_hd__fill_1
XFILLER_22_41 VPWR VGND VPWR VGND sky130_ef_sc_hd__decap_12
XFILLER_22_74 VGND VGND VPWR VPWR sky130_fd_sc_hd__decap_8
XFILLER_22_85 VPWR VGND VPWR VGND sky130_ef_sc_hd__decap_12
XFILLER_3_366 VGND VGND VPWR VPWR sky130_fd_sc_hd__fill_2
XFILLER_3_399 VPWR VGND VPWR VGND sky130_ef_sc_hd__decap_12
XFILLER_78_145 VGND VGND VPWR VPWR sky130_fd_sc_hd__fill_1
XFILLER_66_307 VGND VGND VPWR VPWR sky130_fd_sc_hd__fill_1
Xfanout191 net64 VGND VGND VPWR VPWR net191 sky130_fd_sc_hd__clkbuf_4
XFILLER_93_137 VPWR VGND VPWR VGND sky130_ef_sc_hd__decap_12
Xfanout180 net184 VGND VGND VPWR VPWR net180 sky130_fd_sc_hd__buf_2
XFILLER_78_189 VGND VGND VPWR VPWR sky130_fd_sc_hd__decap_6
XFILLER_47_521 VGND VGND VPWR VPWR sky130_fd_sc_hd__fill_1
XFILLER_47_598 VGND VGND VPWR VPWR sky130_fd_sc_hd__decap_4
XTAP_TAPCELL_ROW_66_1049 VGND VPWR sky130_fd_sc_hd__tapvpwrvgnd_1
XTAP_TAPCELL_ROW_66_1038 VGND VPWR sky130_fd_sc_hd__tapvpwrvgnd_1
XTAP_TAPCELL_ROW_17_457 VGND VPWR sky130_fd_sc_hd__tapvpwrvgnd_1
XTAP_TAPCELL_ROW_45_788 VGND VPWR sky130_fd_sc_hd__tapvpwrvgnd_1
XFILLER_15_473 VGND VGND VPWR VPWR sky130_fd_sc_hd__decap_3
XFILLER_30_421 VPWR VGND VPWR VGND sky130_ef_sc_hd__decap_12
X_4560_ _0310_ _0311_ _0322_ VGND VGND VPWR VPWR _0324_ sky130_fd_sc_hd__a21o_1
XFILLER_8_65 VPWR VGND VPWR VGND sky130_ef_sc_hd__decap_12
X_4491_ net426 net415 net208 net201 VGND VGND VPWR VPWR _0256_ sky130_fd_sc_hd__and4_1
X_3511_ _1092_ _1898_ VGND VGND VPWR VPWR _1920_ sky130_fd_sc_hd__or2_1
XFILLER_116_559 VGND VGND VPWR VPWR sky130_fd_sc_hd__fill_1
X_3442_ net473 net354 VGND VGND VPWR VPWR _1168_ sky130_fd_sc_hd__and2b_1
XTAP_TAPCELL_ROW_77_1178 VGND VPWR sky130_fd_sc_hd__tapvpwrvgnd_1
XFILLER_6_193 VGND VGND VPWR VPWR sky130_fd_sc_hd__decap_3
X_6230_ _2096_ _2097_ _2098_ VGND VGND VPWR VPWR _2099_ sky130_fd_sc_hd__and3_1
XFILLER_103_209 VGND VGND VPWR VPWR sky130_fd_sc_hd__decap_8
X_6161_ net413 net264 net257 net421 VGND VGND VPWR VPWR _2023_ sky130_fd_sc_hd__a22oi_1
X_5112_ _0777_ _0779_ _0878_ _0879_ VGND VGND VPWR VPWR _0880_ sky130_fd_sc_hd__o211a_1
XTAP_TAPCELL_ROW_90_1334 VGND VPWR sky130_fd_sc_hd__tapvpwrvgnd_1
XFILLER_69_134 VPWR VGND VPWR VGND sky130_ef_sc_hd__decap_12
X_6092_ _1945_ _1946_ _1756_ _1798_ VGND VGND VPWR VPWR _1948_ sky130_fd_sc_hd__a211oi_1
X_5043_ _0800_ _0801_ _0802_ VGND VGND VPWR VPWR _0804_ sky130_fd_sc_hd__nand3_1
XFILLER_38_521 VGND VGND VPWR VPWR sky130_fd_sc_hd__decap_8
XFILLER_93_671 VGND VGND VPWR VPWR sky130_fd_sc_hd__fill_1
XFILLER_53_513 VGND VGND VPWR VPWR sky130_fd_sc_hd__fill_1
XFILLER_80_321 VPWR VGND VPWR VGND sky130_ef_sc_hd__decap_12
X_5945_ _1772_ _1785_ _1787_ VGND VGND VPWR VPWR _1788_ sky130_fd_sc_hd__or3_1
XFILLER_80_387 VGND VGND VPWR VPWR sky130_fd_sc_hd__decap_6
X_5876_ _1711_ _1712_ VGND VGND VPWR VPWR _1713_ sky130_fd_sc_hd__nand2_1
X_4827_ _0584_ _0585_ _0581_ VGND VGND VPWR VPWR _0587_ sky130_fd_sc_hd__a21o_1
XFILLER_33_292 VGND VGND VPWR VPWR sky130_fd_sc_hd__decap_8
X_4758_ _0516_ _0517_ _0505_ VGND VGND VPWR VPWR _0519_ sky130_fd_sc_hd__a21o_1
XFILLER_5_609 VGND VGND VPWR VPWR sky130_fd_sc_hd__decap_6
X_4689_ _0381_ _0448_ _0449_ VGND VGND VPWR VPWR _0451_ sky130_fd_sc_hd__nand3b_1
XFILLER_107_526 VPWR VGND VPWR VGND sky130_ef_sc_hd__decap_12
X_3709_ _2909_ VGND VGND VPWR VPWR _2910_ sky130_fd_sc_hd__inv_2
X_6428_ _2153_ _2155_ _2312_ _2315_ VGND VGND VPWR VPWR _2316_ sky130_fd_sc_hd__a211o_1
XFILLER_88_410 VGND VGND VPWR VPWR sky130_fd_sc_hd__decap_8
XFILLER_68_26 VGND VGND VPWR VPWR sky130_fd_sc_hd__fill_2
XFILLER_88_443 VGND VGND VPWR VPWR sky130_fd_sc_hd__decap_6
XFILLER_88_421 VGND VGND VPWR VPWR sky130_fd_sc_hd__decap_4
XFILLER_68_59 VGND VGND VPWR VPWR sky130_fd_sc_hd__decap_8
X_6359_ _2229_ _2238_ VGND VGND VPWR VPWR _2240_ sky130_fd_sc_hd__nor2_1
XFILLER_102_253 VPWR VGND VPWR VGND sky130_ef_sc_hd__decap_12
XFILLER_0_347 VPWR VGND VPWR VGND sky130_ef_sc_hd__decap_12
XTAP_TAPCELL_ROW_110_1570 VGND VPWR sky130_fd_sc_hd__tapvpwrvgnd_1
XFILLER_75_126 VGND VGND VPWR VPWR sky130_fd_sc_hd__decap_6
XFILLER_75_148 VGND VGND VPWR VPWR sky130_fd_sc_hd__decap_4
XFILLER_84_69 VPWR VGND VPWR VGND sky130_ef_sc_hd__decap_12
XFILLER_44_557 VGND VGND VPWR VPWR sky130_fd_sc_hd__decap_8
XFILLER_16_259 VPWR VGND VPWR VGND sky130_ef_sc_hd__decap_12
XFILLER_12_421 VGND VGND VPWR VPWR sky130_fd_sc_hd__decap_8
XFILLER_12_410 VGND VGND VPWR VPWR sky130_fd_sc_hd__decap_8
XTAP_TAPCELL_ROW_14_416 VGND VPWR sky130_fd_sc_hd__tapvpwrvgnd_1
XFILLER_33_51 VGND VGND VPWR VPWR sky130_fd_sc_hd__decap_4
XTAP_TAPCELL_ROW_42_758 VGND VPWR sky130_fd_sc_hd__tapvpwrvgnd_1
XFILLER_8_469 VGND VGND VPWR VPWR sky130_fd_sc_hd__decap_6
XFILLER_113_529 VPWR VGND VPWR VGND sky130_ef_sc_hd__decap_12
XFILLER_106_581 VGND VGND VPWR VPWR sky130_fd_sc_hd__decap_6
XFILLER_94_435 VPWR VGND VPWR VGND sky130_ef_sc_hd__decap_12
XFILLER_75_671 VGND VGND VPWR VPWR sky130_fd_sc_hd__fill_1
XFILLER_62_321 VPWR VGND VPWR VGND sky130_ef_sc_hd__decap_12
XFILLER_35_524 VGND VGND VPWR VPWR sky130_fd_sc_hd__fill_1
XFILLER_35_557 VGND VGND VPWR VPWR sky130_fd_sc_hd__decap_3
X_3991_ net119 _2564_ _3174_ _3179_ VGND VGND VPWR VPWR _alu_i0.Datapath_i.fu_alu_33673_33851.out1\[18\]
+ sky130_fd_sc_hd__a22o_1
XFILLER_74_91 VGND VGND VPWR VPWR sky130_fd_sc_hd__decap_4
XFILLER_62_365 VGND VGND VPWR VPWR sky130_fd_sc_hd__decap_3
XFILLER_95_3 VPWR VGND VPWR VGND sky130_ef_sc_hd__decap_12
X_5730_ _1544_ _1551_ _1552_ VGND VGND VPWR VPWR _1554_ sky130_fd_sc_hd__nand3_2
XFILLER_15_281 VGND VGND VPWR VPWR sky130_fd_sc_hd__decap_8
X_5661_ _1384_ _1392_ _1477_ VGND VGND VPWR VPWR _1478_ sky130_fd_sc_hd__a21oi_2
X_4612_ net393 net215 _0373_ _0374_ VGND VGND VPWR VPWR _0375_ sky130_fd_sc_hd__a22o_1
XFILLER_30_295 VGND VGND VPWR VPWR sky130_fd_sc_hd__decap_8
X_5592_ net361 net429 net331 net325 VGND VGND VPWR VPWR _1403_ sky130_fd_sc_hd__and4_1
X_4543_ net291 net362 _0304_ _0305_ VGND VGND VPWR VPWR _0307_ sky130_fd_sc_hd__a22o_1
Xmax_cap111 _1195_ VGND VGND VPWR VPWR net111 sky130_fd_sc_hd__buf_1
XFILLER_116_389 VGND VGND VPWR VPWR sky130_fd_sc_hd__decap_3
X_4474_ net250 net377 VGND VGND VPWR VPWR _0239_ sky130_fd_sc_hd__and2_1
X_6213_ _2078_ _2079_ VGND VGND VPWR VPWR _2080_ sky130_fd_sc_hd__and2_1
X_3425_ net267 VGND VGND VPWR VPWR _0983_ sky130_fd_sc_hd__inv_2
X_6144_ _1848_ _1851_ _2003_ _2004_ VGND VGND VPWR VPWR _2005_ sky130_fd_sc_hd__o211ai_4
X_6075_ _1919_ _1927_ _1928_ VGND VGND VPWR VPWR _1929_ sky130_fd_sc_hd__nand3_1
XFILLER_38_29 VPWR VGND VPWR VGND sky130_ef_sc_hd__decap_12
X_5026_ _0690_ _0692_ VGND VGND VPWR VPWR _0786_ sky130_fd_sc_hd__or2_1
XFILLER_81_641 VPWR VGND VPWR VGND sky130_ef_sc_hd__decap_12
XFILLER_26_524 VGND VGND VPWR VPWR sky130_fd_sc_hd__decap_8
XFILLER_26_557 VPWR VGND VPWR VGND sky130_ef_sc_hd__decap_12
XFILLER_26_579 VGND VGND VPWR VPWR sky130_fd_sc_hd__decap_8
XFILLER_81_685 VGND VGND VPWR VPWR sky130_fd_sc_hd__decap_6
XFILLER_80_173 VPWR VGND VPWR VGND sky130_ef_sc_hd__decap_12
XFILLER_13_218 VGND VGND VPWR VPWR sky130_fd_sc_hd__decap_6
X_5928_ _1621_ _1622_ VGND VGND VPWR VPWR _1770_ sky130_fd_sc_hd__nand2_1
X_5859_ _1691_ _1693_ _1555_ _1557_ VGND VGND VPWR VPWR _1695_ sky130_fd_sc_hd__a211o_1
XFILLER_21_295 VGND VGND VPWR VPWR sky130_fd_sc_hd__decap_3
XFILLER_107_389 VGND VGND VPWR VPWR sky130_fd_sc_hd__decap_3
XFILLER_79_69 VGND VGND VPWR VPWR sky130_fd_sc_hd__decap_8
XFILLER_88_251 VGND VGND VPWR VPWR sky130_fd_sc_hd__fill_1
XFILLER_103_573 VPWR VGND VPWR VGND sky130_ef_sc_hd__decap_12
XFILLER_95_68 VGND VGND VPWR VPWR sky130_fd_sc_hd__fill_2
XFILLER_88_295 VGND VGND VPWR VPWR sky130_fd_sc_hd__fill_2
XFILLER_76_457 VPWR VGND VPWR VGND sky130_ef_sc_hd__decap_12
XFILLER_57_660 VPWR VGND VPWR VGND sky130_ef_sc_hd__decap_12
XTAP_TAPCELL_ROW_47_817 VGND VPWR sky130_fd_sc_hd__tapvpwrvgnd_1
XFILLER_56_170 VGND VGND VPWR VPWR sky130_fd_sc_hd__decap_4
XFILLER_44_321 VGND VGND VPWR VPWR sky130_fd_sc_hd__decap_6
XTAP_TAPCELL_ROW_63_1008 VGND VPWR sky130_fd_sc_hd__tapvpwrvgnd_1
XFILLER_44_365 VPWR VGND VPWR VGND sky130_ef_sc_hd__decap_12
XFILLER_71_184 VGND VGND VPWR VPWR sky130_fd_sc_hd__decap_6
XTAP_TAPCELL_ROW_27_574 VGND VPWR sky130_fd_sc_hd__tapvpwrvgnd_1
XFILLER_32_516 VGND VGND VPWR VPWR sky130_fd_sc_hd__decap_8
XFILLER_44_61 VGND VGND VPWR VPWR sky130_fd_sc_hd__fill_1
XFILLER_12_240 VPWR VGND VPWR VGND sky130_ef_sc_hd__decap_12
XFILLER_8_299 VGND VGND VPWR VPWR sky130_fd_sc_hd__decap_3
XFILLER_99_505 VGND VGND VPWR VPWR sky130_fd_sc_hd__fill_1
XTAP_TAPCELL_ROW_74_1137 VGND VPWR sky130_fd_sc_hd__tapvpwrvgnd_1
XFILLER_5_55 VGND VGND VPWR VPWR sky130_fd_sc_hd__fill_1
XFILLER_113_337 VPWR VGND VPWR VGND sky130_ef_sc_hd__decap_12
X_4190_ net427 net53 VGND VGND VPWR VPWR _3369_ sky130_fd_sc_hd__nor2_1
XFILLER_94_210 VGND VGND VPWR VPWR sky130_fd_sc_hd__fill_2
XFILLER_94_232 VGND VGND VPWR VPWR sky130_fd_sc_hd__fill_1
XFILLER_10_3 VPWR VGND VPWR VGND sky130_ef_sc_hd__decap_12
XFILLER_82_438 VPWR VGND VPWR VGND sky130_ef_sc_hd__decap_12
X_6900_ net182 _alu_i0.Datapath_i.fu_alu_33673_33851.out1\[26\] VGND VGND VPWR VPWR
+ _alu_i0.Datapath_i.reg_0.reg_out1\[26\] sky130_fd_sc_hd__dfxtp_1
XTAP_TAPCELL_ROW_85_1266 VGND VPWR sky130_fd_sc_hd__tapvpwrvgnd_1
XFILLER_63_652 VPWR VGND VPWR VGND sky130_ef_sc_hd__decap_12
XFILLER_23_505 VGND VGND VPWR VPWR sky130_fd_sc_hd__decap_8
X_6831_ _2577_ _2754_ VGND VGND VPWR VPWR _2755_ sky130_fd_sc_hd__xnor2_1
XTAP_TAPCELL_ROW_85_1277 VGND VPWR sky130_fd_sc_hd__tapvpwrvgnd_1
XFILLER_63_685 VGND VGND VPWR VPWR sky130_fd_sc_hd__decap_6
XFILLER_50_313 VPWR VGND VPWR VGND sky130_ef_sc_hd__decap_12
XFILLER_62_195 VGND VGND VPWR VPWR sky130_fd_sc_hd__fill_1
X_6762_ _2674_ _2675_ _2676_ _2677_ VGND VGND VPWR VPWR _2679_ sky130_fd_sc_hd__a22o_1
X_3974_ _3111_ _3144_ _3142_ VGND VGND VPWR VPWR _3163_ sky130_fd_sc_hd__o21a_1
X_6693_ _2602_ _2603_ VGND VGND VPWR VPWR _2604_ sky130_fd_sc_hd__nor2_1
X_5713_ _1532_ _1533_ VGND VGND VPWR VPWR _1535_ sky130_fd_sc_hd__xor2_2
X_5644_ _1455_ _1457_ _1458_ net149 VGND VGND VPWR VPWR _1460_ sky130_fd_sc_hd__a31o_1
XFILLER_108_109 VGND VGND VPWR VPWR sky130_fd_sc_hd__decap_4
X_5575_ _1261_ _1383_ VGND VGND VPWR VPWR _1384_ sky130_fd_sc_hd__nand2_1
X_4526_ net424 net196 VGND VGND VPWR VPWR _0290_ sky130_fd_sc_hd__nand2_1
XFILLER_116_197 VPWR VGND VPWR VGND sky130_ef_sc_hd__decap_12
XFILLER_116_186 VGND VGND VPWR VPWR sky130_fd_sc_hd__fill_1
X_4457_ _0220_ _0221_ _0175_ VGND VGND VPWR VPWR _0223_ sky130_fd_sc_hd__a21oi_1
X_3408_ net234 VGND VGND VPWR VPWR _0797_ sky130_fd_sc_hd__inv_2
X_4388_ _0153_ _0154_ VGND VGND VPWR VPWR _0155_ sky130_fd_sc_hd__nor2_1
X_6127_ _1831_ _1833_ _1984_ _1985_ VGND VGND VPWR VPWR _1987_ sky130_fd_sc_hd__o211ai_4
XFILLER_58_457 VPWR VGND VPWR VGND sky130_ef_sc_hd__decap_12
XFILLER_100_587 VGND VGND VPWR VPWR sky130_fd_sc_hd__fill_1
XFILLER_85_254 VGND VGND VPWR VPWR sky130_fd_sc_hd__decap_8
XFILLER_73_416 VGND VGND VPWR VPWR sky130_fd_sc_hd__decap_3
X_6058_ net219 net330 _3048_ VGND VGND VPWR VPWR _1911_ sky130_fd_sc_hd__nand3_1
XFILLER_39_671 VGND VGND VPWR VPWR sky130_fd_sc_hd__fill_1
X_5009_ _0764_ _0767_ _0747_ VGND VGND VPWR VPWR _0768_ sky130_fd_sc_hd__a21oi_2
XFILLER_73_449 VPWR VGND VPWR VGND sky130_ef_sc_hd__decap_12
XFILLER_26_321 VPWR VGND VPWR VGND sky130_ef_sc_hd__decap_12
XFILLER_26_365 VPWR VGND VPWR VGND sky130_ef_sc_hd__decap_12
XFILLER_81_15 VPWR VGND VPWR VGND sky130_ef_sc_hd__decap_12
XFILLER_54_685 VGND VGND VPWR VPWR sky130_fd_sc_hd__fill_1
XFILLER_14_516 VPWR VGND VPWR VGND sky130_ef_sc_hd__decap_12
XFILLER_53_184 VPWR VGND VPWR VGND sky130_ef_sc_hd__decap_12
XTAP_TAPCELL_ROW_24_544 VGND VPWR sky130_fd_sc_hd__tapvpwrvgnd_1
XFILLER_14_53 VPWR VGND VPWR VGND sky130_ef_sc_hd__decap_12
XTAP_TAPCELL_ROW_52_875 VGND VPWR sky130_fd_sc_hd__tapvpwrvgnd_1
XFILLER_108_643 VGND VGND VPWR VPWR sky130_fd_sc_hd__fill_1
XFILLER_5_225 VPWR VGND VPWR VGND sky130_ef_sc_hd__decap_12
XFILLER_30_41 VPWR VGND VPWR VGND sky130_ef_sc_hd__decap_12
XFILLER_107_142 VPWR VGND VPWR VGND sky130_ef_sc_hd__decap_12
XFILLER_30_85 VPWR VGND VPWR VGND sky130_ef_sc_hd__decap_12
XFILLER_110_307 VGND VGND VPWR VPWR sky130_fd_sc_hd__fill_1
XFILLER_39_83 VPWR VGND VPWR VGND sky130_ef_sc_hd__decap_12
XFILLER_49_435 VPWR VGND VPWR VGND sky130_ef_sc_hd__decap_12
XPHY_EDGE_ROW_101_Right_101 VGND VGND VPWR VPWR sky130_fd_sc_hd__decap_3
XFILLER_91_213 VGND VGND VPWR VPWR sky130_fd_sc_hd__decap_8
XFILLER_29_181 VPWR VGND VPWR VGND sky130_ef_sc_hd__decap_12
XFILLER_45_641 VPWR VGND VPWR VGND sky130_ef_sc_hd__decap_12
XFILLER_60_600 VGND VGND VPWR VPWR sky130_fd_sc_hd__decap_8
XFILLER_55_93 VGND VGND VPWR VPWR sky130_fd_sc_hd__fill_1
XFILLER_44_162 VGND VGND VPWR VPWR sky130_fd_sc_hd__fill_1
XFILLER_45_685 VGND VGND VPWR VPWR sky130_fd_sc_hd__decap_6
XFILLER_44_184 VGND VGND VPWR VPWR sky130_fd_sc_hd__fill_2
XFILLER_9_520 VGND VGND VPWR VPWR sky130_fd_sc_hd__fill_2
X_3690_ _1266_ _2884_ _2889_ net120 _2891_ VGND VGND VPWR VPWR _2892_ sky130_fd_sc_hd__a221o_1
XFILLER_9_597 VPWR VGND VPWR VGND sky130_ef_sc_hd__decap_12
X_5360_ _1148_ _1149_ VGND VGND VPWR VPWR _1150_ sky130_fd_sc_hd__xnor2_2
XFILLER_114_613 VPWR VGND VPWR VGND sky130_ef_sc_hd__decap_12
X_4311_ _0079_ _0080_ VGND VGND VPWR VPWR _0081_ sky130_fd_sc_hd__xor2_1
X_5291_ _0966_ _0968_ _1073_ _1074_ VGND VGND VPWR VPWR _1075_ sky130_fd_sc_hd__o211a_1
XFILLER_114_657 VPWR VGND VPWR VGND sky130_ef_sc_hd__decap_12
X_4242_ net24 net56 VGND VGND VPWR VPWR _0018_ sky130_fd_sc_hd__nand2_1
XFILLER_101_329 VGND VGND VPWR VPWR sky130_fd_sc_hd__decap_6
X_4173_ _3351_ _3352_ VGND VGND VPWR VPWR _3353_ sky130_fd_sc_hd__or2_2
XFILLER_95_585 VPWR VGND VPWR VGND sky130_ef_sc_hd__decap_12
XFILLER_55_405 VPWR VGND VPWR VGND sky130_ef_sc_hd__decap_12
XFILLER_55_449 VPWR VGND VPWR VGND sky130_ef_sc_hd__decap_12
XFILLER_36_641 VGND VGND VPWR VPWR sky130_fd_sc_hd__decap_3
X_6814_ net374 net263 VGND VGND VPWR VPWR _2736_ sky130_fd_sc_hd__nand2_1
XFILLER_23_335 VGND VGND VPWR VPWR sky130_fd_sc_hd__fill_1
X_3957_ _3111_ _3122_ _3144_ _3145_ VGND VGND VPWR VPWR _3147_ sky130_fd_sc_hd__a31o_1
XTAP_TAPCELL_ROW_21_503 VGND VPWR sky130_fd_sc_hd__tapvpwrvgnd_1
XFILLER_23_368 VPWR VGND VPWR VGND sky130_ef_sc_hd__decap_12
X_6745_ _2013_ _2330_ _2331_ _2491_ _2328_ VGND VGND VPWR VPWR _2661_ sky130_fd_sc_hd__a2111o_1
XFILLER_50_165 VPWR VGND VPWR VGND sky130_ef_sc_hd__decap_12
XTAP_TAPCELL_ROW_98_1424 VGND VPWR sky130_fd_sc_hd__tapvpwrvgnd_1
X_3888_ _3051_ _3056_ _3080_ VGND VGND VPWR VPWR _3081_ sky130_fd_sc_hd__o21ba_1
X_6676_ _2573_ _2584_ VGND VGND VPWR VPWR _2585_ sky130_fd_sc_hd__xnor2_1
X_5627_ _1316_ _1318_ _1439_ _1440_ VGND VGND VPWR VPWR _1442_ sky130_fd_sc_hd__a211o_1
X_5558_ _1354_ _1363_ _1365_ VGND VGND VPWR VPWR _1366_ sky130_fd_sc_hd__and3_1
X_4509_ _0219_ _0271_ _0272_ VGND VGND VPWR VPWR _0274_ sky130_fd_sc_hd__and3_1
X_5489_ _1289_ _1290_ VGND VGND VPWR VPWR _1291_ sky130_fd_sc_hd__and2b_1
XFILLER_76_15 VPWR VGND VPWR VGND sky130_ef_sc_hd__decap_12
XFILLER_76_37 VGND VGND VPWR VPWR sky130_fd_sc_hd__decap_3
XFILLER_58_210 VGND VGND VPWR VPWR sky130_fd_sc_hd__decap_3
XFILLER_100_362 VGND VGND VPWR VPWR sky130_fd_sc_hd__fill_2
XFILLER_86_574 VGND VGND VPWR VPWR sky130_fd_sc_hd__fill_1
XTAP_TAPCELL_ROW_29_603 VGND VPWR sky130_fd_sc_hd__tapvpwrvgnd_1
XFILLER_58_287 VGND VGND VPWR VPWR sky130_fd_sc_hd__fill_1
XTAP_TAPCELL_ROW_57_934 VGND VPWR sky130_fd_sc_hd__tapvpwrvgnd_1
XTAP_TAPCELL_ROW_107_1531 VGND VPWR sky130_fd_sc_hd__tapvpwrvgnd_1
XTAP_TAPCELL_ROW_1_261 VGND VPWR sky130_fd_sc_hd__tapvpwrvgnd_1
XFILLER_27_641 VPWR VGND VPWR VGND sky130_ef_sc_hd__decap_12
XFILLER_26_162 VPWR VGND VPWR VGND sky130_ef_sc_hd__decap_12
XFILLER_27_685 VGND VGND VPWR VPWR sky130_fd_sc_hd__decap_6
XFILLER_81_290 VPWR VGND VPWR VGND sky130_ef_sc_hd__decap_12
XTAP_TAPCELL_ROW_37_691 VGND VPWR sky130_fd_sc_hd__tapvpwrvgnd_1
XFILLER_41_110 VGND VGND VPWR VPWR sky130_fd_sc_hd__fill_2
XFILLER_41_143 VGND VGND VPWR VPWR sky130_fd_sc_hd__decap_4
XFILLER_6_545 VPWR VGND VPWR VGND sky130_ef_sc_hd__decap_12
XFILLER_41_73 VGND VGND VPWR VPWR sky130_fd_sc_hd__fill_1
XFILLER_41_84 VGND VGND VPWR VPWR sky130_fd_sc_hd__decap_8
XFILLER_108_473 VGND VGND VPWR VPWR sky130_fd_sc_hd__decap_3
XFILLER_6_589 VPWR VGND VPWR VGND sky130_ef_sc_hd__decap_12
XPHY_EDGE_ROW_102_Left_219 VGND VGND VPWR VPWR sky130_fd_sc_hd__decap_3
XTAP_TAPCELL_ROW_71_1107 VGND VPWR sky130_fd_sc_hd__tapvpwrvgnd_1
XTAP_TAPCELL_ROW_9_361 VGND VPWR sky130_fd_sc_hd__tapvpwrvgnd_1
XFILLER_96_316 VPWR VGND VPWR VGND sky130_ef_sc_hd__decap_12
XFILLER_96_305 VGND VGND VPWR VPWR sky130_fd_sc_hd__decap_3
XFILLER_1_250 VGND VGND VPWR VPWR sky130_fd_sc_hd__decap_4
XFILLER_49_254 VPWR VGND VPWR VGND sky130_ef_sc_hd__decap_12
XFILLER_92_533 VPWR VGND VPWR VGND sky130_ef_sc_hd__decap_12
XFILLER_92_511 VGND VGND VPWR VPWR sky130_fd_sc_hd__decap_4
XFILLER_37_449 VPWR VGND VPWR VGND sky130_ef_sc_hd__decap_12
XFILLER_52_419 VGND VGND VPWR VPWR sky130_fd_sc_hd__fill_1
XFILLER_17_162 VGND VGND VPWR VPWR sky130_fd_sc_hd__decap_6
XFILLER_18_685 VGND VGND VPWR VPWR sky130_fd_sc_hd__fill_1
XPHY_EDGE_ROW_111_Left_228 VGND VGND VPWR VPWR sky130_fd_sc_hd__decap_3
X_4860_ _0617_ _0619_ _0615_ VGND VGND VPWR VPWR _0620_ sky130_fd_sc_hd__o21a_1
XTAP_TAPCELL_ROW_82_1236 VGND VPWR sky130_fd_sc_hd__tapvpwrvgnd_1
XFILLER_45_493 VGND VGND VPWR VPWR sky130_fd_sc_hd__decap_8
X_3811_ net345 net431 VGND VGND VPWR VPWR _3007_ sky130_fd_sc_hd__nand2b_1
X_4791_ net424 net335 net327 net458 VGND VGND VPWR VPWR _0551_ sky130_fd_sc_hd__a22o_1
XANTENNA_39 net418 VGND VGND VPWR VPWR sky130_fd_sc_hd__diode_2
XANTENNA_28 net333 VGND VGND VPWR VPWR sky130_fd_sc_hd__diode_2
XANTENNA_17 net29 VGND VGND VPWR VPWR sky130_fd_sc_hd__diode_2
X_6530_ _2424_ _2425_ _2384_ VGND VGND VPWR VPWR _2427_ sky130_fd_sc_hd__o21ai_1
X_3742_ net117 _2939_ _2941_ _2935_ VGND VGND VPWR VPWR _alu_i0.Datapath_i.fu_alu_33673_33851.out1\[7\]
+ sky130_fd_sc_hd__a211o_1
X_3673_ _2842_ _2851_ VGND VGND VPWR VPWR _2875_ sky130_fd_sc_hd__nor2_1
X_6461_ _2174_ _2178_ _2349_ VGND VGND VPWR VPWR _2351_ sky130_fd_sc_hd__or3_1
X_5412_ _1089_ _1091_ VGND VGND VPWR VPWR _1207_ sky130_fd_sc_hd__nor2_1
X_6392_ _2274_ _2275_ VGND VGND VPWR VPWR _2276_ sky130_fd_sc_hd__nand2_1
XFILLER_114_421 VPWR VGND VPWR VGND sky130_ef_sc_hd__decap_12
Xoutput102 net102 VGND VGND VPWR VPWR return_port[3] sky130_fd_sc_hd__clkbuf_4
X_5343_ _1128_ _1129_ _1118_ VGND VGND VPWR VPWR _1131_ sky130_fd_sc_hd__a21oi_1
XFILLER_99_154 VPWR VGND VPWR VGND sky130_ef_sc_hd__decap_12
XFILLER_99_143 VGND VGND VPWR VPWR sky130_fd_sc_hd__decap_3
XTAP_TAPCELL_ROW_93_1365 VGND VPWR sky130_fd_sc_hd__tapvpwrvgnd_1
XFILLER_99_176 VPWR VGND VPWR VGND sky130_ef_sc_hd__decap_12
XFILLER_87_305 VPWR VGND VPWR VGND sky130_ef_sc_hd__decap_12
X_5274_ _1052_ _1053_ _1054_ VGND VGND VPWR VPWR _1056_ sky130_fd_sc_hd__a21o_1
XFILLER_101_137 VPWR VGND VPWR VGND sky130_ef_sc_hd__decap_12
XFILLER_87_349 VPWR VGND VPWR VGND sky130_ef_sc_hd__decap_12
X_4225_ net348 _0906_ _2172_ VGND VGND VPWR VPWR _3403_ sky130_fd_sc_hd__o21ai_1
X_4156_ _3321_ _3335_ _3334_ VGND VGND VPWR VPWR _3337_ sky130_fd_sc_hd__o21ai_1
XFILLER_95_393 VGND VGND VPWR VPWR sky130_fd_sc_hd__decap_3
XFILLER_83_511 VGND VGND VPWR VPWR sky130_fd_sc_hd__decap_6
XFILLER_55_202 VPWR VGND VPWR VGND sky130_ef_sc_hd__decap_12
XFILLER_46_29 VGND VGND VPWR VPWR sky130_fd_sc_hd__fill_2
XTAP_TAPCELL_ROW_54_904 VGND VPWR sky130_fd_sc_hd__tapvpwrvgnd_1
X_4087_ net124 _3255_ _3267_ _3270_ VGND VGND VPWR VPWR _3271_ sky130_fd_sc_hd__a31o_1
XFILLER_55_279 VGND VGND VPWR VPWR sky130_fd_sc_hd__fill_1
XFILLER_11_305 VGND VGND VPWR VPWR sky130_fd_sc_hd__decap_3
XTAP_TAPCELL_ROW_34_661 VGND VPWR sky130_fd_sc_hd__tapvpwrvgnd_1
XTAP_TAPCELL_ROW_102_1472 VGND VPWR sky130_fd_sc_hd__tapvpwrvgnd_1
X_4989_ _2335_ _0745_ VGND VGND VPWR VPWR _0747_ sky130_fd_sc_hd__xnor2_1
XTAP_TAPCELL_ROW_62_992 VGND VPWR sky130_fd_sc_hd__tapvpwrvgnd_1
XFILLER_11_327 VGND VGND VPWR VPWR sky130_fd_sc_hd__decap_3
XFILLER_51_485 VPWR VGND VPWR VGND sky130_ef_sc_hd__decap_12
XFILLER_7_309 VPWR VGND VPWR VGND sky130_ef_sc_hd__decap_12
X_6728_ _2601_ _2639_ VGND VGND VPWR VPWR _2643_ sky130_fd_sc_hd__xor2_1
XFILLER_109_237 VPWR VGND VPWR VGND sky130_ef_sc_hd__decap_12
X_6659_ _2565_ _2566_ VGND VGND VPWR VPWR _2567_ sky130_fd_sc_hd__xor2_1
XFILLER_11_65 VGND VGND VPWR VPWR sky130_fd_sc_hd__fill_1
XFILLER_3_559 VGND VGND VPWR VPWR sky130_fd_sc_hd__fill_1
XFILLER_105_487 VGND VGND VPWR VPWR sky130_fd_sc_hd__fill_1
XFILLER_87_47 VGND VGND VPWR VPWR sky130_fd_sc_hd__decap_8
XTAP_TAPCELL_ROW_6_320 VGND VPWR sky130_fd_sc_hd__tapvpwrvgnd_1
Xfanout340 net343 VGND VGND VPWR VPWR net340 sky130_fd_sc_hd__buf_2
Xfanout362 net363 VGND VGND VPWR VPWR net362 sky130_fd_sc_hd__buf_2
Xfanout351 net353 VGND VGND VPWR VPWR net351 sky130_fd_sc_hd__clkbuf_4
Xfanout373 net31 VGND VGND VPWR VPWR net373 sky130_fd_sc_hd__clkbuf_4
Xfanout384 net3 VGND VGND VPWR VPWR net384 sky130_fd_sc_hd__buf_2
XFILLER_101_671 VGND VGND VPWR VPWR sky130_fd_sc_hd__fill_1
Xfanout395 net396 VGND VGND VPWR VPWR net395 sky130_fd_sc_hd__clkbuf_4
XFILLER_100_192 VGND VGND VPWR VPWR sky130_fd_sc_hd__decap_4
XFILLER_74_566 VPWR VGND VPWR VGND sky130_ef_sc_hd__decap_12
XFILLER_19_449 VPWR VGND VPWR VGND sky130_ef_sc_hd__decap_12
XFILLER_27_460 VGND VGND VPWR VPWR sky130_fd_sc_hd__fill_1
XFILLER_27_471 VGND VGND VPWR VPWR sky130_fd_sc_hd__decap_8
XFILLER_30_669 VPWR VGND VPWR VGND sky130_ef_sc_hd__decap_12
Xinput37 b[13] VGND VGND VPWR VPWR net37 sky130_fd_sc_hd__buf_1
Xinput26 a[3] VGND VGND VPWR VPWR net26 sky130_fd_sc_hd__buf_4
Xinput15 a[22] VGND VGND VPWR VPWR net15 sky130_fd_sc_hd__buf_1
Xinput59 b[4] VGND VGND VPWR VPWR net59 sky130_fd_sc_hd__buf_1
XTAP_TAPCELL_ROW_12_399 VGND VPWR sky130_fd_sc_hd__tapvpwrvgnd_1
Xinput48 b[23] VGND VGND VPWR VPWR net48 sky130_fd_sc_hd__clkbuf_1
XFILLER_115_229 VGND VGND VPWR VPWR sky130_fd_sc_hd__fill_1
XFILLER_69_305 VPWR VGND VPWR VGND sky130_ef_sc_hd__decap_12
XFILLER_2_581 VGND VGND VPWR VPWR sky130_fd_sc_hd__decap_6
X_4010_ _3191_ _3196_ _3197_ VGND VGND VPWR VPWR _alu_i0.Datapath_i.fu_alu_33673_33851.out1\[19\]
+ sky130_fd_sc_hd__or3b_1
XFILLER_77_393 VGND VGND VPWR VPWR sky130_fd_sc_hd__decap_8
XFILLER_25_419 VGND VGND VPWR VPWR sky130_fd_sc_hd__decap_8
XFILLER_37_279 VGND VGND VPWR VPWR sky130_fd_sc_hd__fill_1
X_5961_ _1804_ _1805_ VGND VGND VPWR VPWR _1806_ sky130_fd_sc_hd__xnor2_1
XFILLER_52_205 VPWR VGND VPWR VGND sky130_ef_sc_hd__decap_12
X_4912_ _0668_ _0669_ _0662_ VGND VGND VPWR VPWR _0671_ sky130_fd_sc_hd__a21o_1
XFILLER_33_430 VPWR VGND VPWR VGND sky130_ef_sc_hd__decap_12
XFILLER_52_249 VGND VGND VPWR VPWR sky130_fd_sc_hd__decap_3
X_5892_ net419 net267 _1727_ _1728_ VGND VGND VPWR VPWR _1730_ sky130_fd_sc_hd__o2bb2a_1
X_4843_ _0600_ _0601_ _0561_ VGND VGND VPWR VPWR _0603_ sky130_fd_sc_hd__a21oi_1
XFILLER_20_102 VPWR VGND VPWR VGND sky130_ef_sc_hd__decap_12
XTAP_TAPCELL_ROW_31_620 VGND VPWR sky130_fd_sc_hd__tapvpwrvgnd_1
X_4774_ _0431_ _0433_ _0533_ _0534_ VGND VGND VPWR VPWR _0535_ sky130_fd_sc_hd__a211oi_2
XFILLER_20_157 VGND VGND VPWR VPWR sky130_fd_sc_hd__decap_8
X_3725_ _2920_ _2924_ VGND VGND VPWR VPWR _2925_ sky130_fd_sc_hd__or2_1
X_6513_ net174 net319 VGND VGND VPWR VPWR _2408_ sky130_fd_sc_hd__nand2_1
X_6444_ _2328_ _2332_ VGND VGND VPWR VPWR _2333_ sky130_fd_sc_hd__xnor2_1
X_3656_ _1386_ _1452_ net246 VGND VGND VPWR VPWR _2859_ sky130_fd_sc_hd__mux2_1
X_3587_ _2597_ _2630_ net155 VGND VGND VPWR VPWR _2750_ sky130_fd_sc_hd__mux2_1
X_6375_ _2254_ _2255_ _2058_ _2060_ VGND VGND VPWR VPWR _2257_ sky130_fd_sc_hd__o211ai_2
XFILLER_88_625 VPWR VGND VPWR VGND sky130_ef_sc_hd__decap_12
X_5326_ _1103_ _1111_ VGND VGND VPWR VPWR _1112_ sky130_fd_sc_hd__xor2_1
XFILLER_0_529 VGND VGND VPWR VPWR sky130_fd_sc_hd__decap_3
XFILLER_102_413 VGND VGND VPWR VPWR sky130_fd_sc_hd__fill_2
XFILLER_87_135 VPWR VGND VPWR VGND sky130_ef_sc_hd__decap_12
XFILLER_87_113 VGND VGND VPWR VPWR sky130_fd_sc_hd__decap_6
X_5257_ _1034_ _1035_ _0925_ _0930_ VGND VGND VPWR VPWR _1038_ sky130_fd_sc_hd__o211a_1
XFILLER_102_468 VGND VGND VPWR VPWR sky130_fd_sc_hd__decap_8
XFILLER_88_669 VPWR VGND VPWR VGND sky130_ef_sc_hd__decap_12
X_4208_ net234 _3386_ VGND VGND VPWR VPWR _3387_ sky130_fd_sc_hd__or2_1
X_5188_ _0811_ _0815_ _0962_ VGND VGND VPWR VPWR _0963_ sky130_fd_sc_hd__o21a_1
XFILLER_56_500 VGND VGND VPWR VPWR sky130_fd_sc_hd__decap_4
XTAP_TAPCELL_ROW_39_720 VGND VPWR sky130_fd_sc_hd__tapvpwrvgnd_1
XFILLER_56_566 VGND VGND VPWR VPWR sky130_fd_sc_hd__decap_4
XFILLER_56_533 VGND VGND VPWR VPWR sky130_fd_sc_hd__decap_4
X_4139_ _3300_ _3314_ VGND VGND VPWR VPWR _3321_ sky130_fd_sc_hd__and2_1
XFILLER_56_577 VGND VGND VPWR VPWR sky130_fd_sc_hd__fill_1
XFILLER_43_205 VPWR VGND VPWR VGND sky130_ef_sc_hd__decap_12
XTAP_TAPCELL_ROW_104_1501 VGND VPWR sky130_fd_sc_hd__tapvpwrvgnd_1
XFILLER_12_625 VPWR VGND VPWR VGND sky130_ef_sc_hd__decap_12
XFILLER_11_113 VPWR VGND VPWR VGND sky130_ef_sc_hd__decap_12
XFILLER_24_485 VGND VGND VPWR VPWR sky130_fd_sc_hd__decap_3
XFILLER_12_669 VPWR VGND VPWR VGND sky130_ef_sc_hd__decap_12
XFILLER_22_53 VPWR VGND VPWR VGND sky130_ef_sc_hd__decap_12
XFILLER_22_97 VPWR VGND VPWR VGND sky130_ef_sc_hd__decap_12
XTAP_TAPCELL_ROW_115_1630 VGND VPWR sky130_fd_sc_hd__tapvpwrvgnd_1
XFILLER_105_240 VPWR VGND VPWR VGND sky130_ef_sc_hd__decap_12
XFILLER_3_389 VGND VGND VPWR VPWR sky130_fd_sc_hd__decap_3
Xfanout181 net183 VGND VGND VPWR VPWR net181 sky130_fd_sc_hd__clkbuf_2
XFILLER_87_691 VGND VGND VPWR VPWR sky130_fd_sc_hd__fill_1
Xfanout192 net197 VGND VGND VPWR VPWR net192 sky130_fd_sc_hd__clkbuf_4
Xfanout170 net173 VGND VGND VPWR VPWR net170 sky130_fd_sc_hd__buf_2
XFILLER_59_371 VGND VGND VPWR VPWR sky130_fd_sc_hd__fill_1
XFILLER_93_149 VPWR VGND VPWR VGND sky130_ef_sc_hd__decap_12
XFILLER_59_393 VPWR VGND VPWR VGND sky130_ef_sc_hd__decap_12
XFILLER_74_374 VGND VGND VPWR VPWR sky130_fd_sc_hd__decap_6
XFILLER_74_363 VGND VGND VPWR VPWR sky130_fd_sc_hd__fill_1
XFILLER_19_279 VGND VGND VPWR VPWR sky130_fd_sc_hd__fill_1
XFILLER_74_396 VGND VGND VPWR VPWR sky130_fd_sc_hd__fill_2
XTAP_TAPCELL_ROW_66_1039 VGND VPWR sky130_fd_sc_hd__tapvpwrvgnd_1
XFILLER_15_441 VGND VGND VPWR VPWR sky130_fd_sc_hd__decap_6
XTAP_TAPCELL_ROW_17_458 VGND VPWR sky130_fd_sc_hd__tapvpwrvgnd_1
XFILLER_15_485 VPWR VGND VPWR VGND sky130_ef_sc_hd__decap_12
XTAP_TAPCELL_ROW_45_789 VGND VPWR sky130_fd_sc_hd__tapvpwrvgnd_1
XFILLER_30_433 VGND VGND VPWR VPWR sky130_fd_sc_hd__decap_4
XFILLER_30_477 VGND VGND VPWR VPWR sky130_fd_sc_hd__decap_6
XFILLER_116_505 VPWR VGND VPWR VGND sky130_ef_sc_hd__decap_12
X_3510_ _1092_ _1898_ VGND VGND VPWR VPWR _1909_ sky130_fd_sc_hd__nand2_1
XFILLER_11_691 VGND VGND VPWR VPWR sky130_fd_sc_hd__fill_1
XFILLER_8_77 VGND VGND VPWR VPWR sky130_fd_sc_hd__decap_6
X_4490_ net407 net217 VGND VGND VPWR VPWR _0255_ sky130_fd_sc_hd__nand2_1
XFILLER_7_673 VPWR VGND VPWR VGND sky130_ef_sc_hd__decap_12
XTAP_TAPCELL_ROW_77_1179 VGND VPWR sky130_fd_sc_hd__tapvpwrvgnd_1
X_3441_ net473 net163 VGND VGND VPWR VPWR _1157_ sky130_fd_sc_hd__and2_1
X_6160_ net421 net413 net263 net256 VGND VGND VPWR VPWR _2022_ sky130_fd_sc_hd__and4_1
X_5111_ _0876_ _0877_ _0770_ _0772_ VGND VGND VPWR VPWR _0879_ sky130_fd_sc_hd__a211o_1
XTAP_TAPCELL_ROW_90_1335 VGND VPWR sky130_fd_sc_hd__tapvpwrvgnd_1
XFILLER_111_232 VGND VGND VPWR VPWR sky130_fd_sc_hd__decap_4
XFILLER_97_477 VGND VGND VPWR VPWR sky130_fd_sc_hd__fill_1
XFILLER_85_617 VPWR VGND VPWR VGND sky130_ef_sc_hd__decap_12
XFILLER_69_146 VPWR VGND VPWR VGND sky130_ef_sc_hd__decap_12
XFILLER_57_308 VGND VGND VPWR VPWR sky130_fd_sc_hd__fill_2
X_6091_ _1756_ _1798_ _1945_ _1946_ VGND VGND VPWR VPWR _1947_ sky130_fd_sc_hd__o211a_1
X_5042_ _0801_ _0802_ _0800_ VGND VGND VPWR VPWR _0803_ sky130_fd_sc_hd__a21o_1
XFILLER_65_352 VPWR VGND VPWR VGND sky130_ef_sc_hd__decap_12
XFILLER_53_503 VGND VGND VPWR VPWR sky130_fd_sc_hd__fill_1
XFILLER_80_333 VPWR VGND VPWR VGND sky130_ef_sc_hd__decap_12
X_5944_ _1782_ _1783_ _1784_ VGND VGND VPWR VPWR _1787_ sky130_fd_sc_hd__a21oi_1
XFILLER_43_19 VPWR VGND VPWR VGND sky130_ef_sc_hd__decap_12
X_5875_ _1709_ _1710_ _1571_ _1574_ VGND VGND VPWR VPWR _1712_ sky130_fd_sc_hd__a211o_1
X_4826_ _0581_ _0584_ _0585_ VGND VGND VPWR VPWR _0586_ sky130_fd_sc_hd__nand3_2
X_4757_ _0505_ _0516_ _0517_ VGND VGND VPWR VPWR _0518_ sky130_fd_sc_hd__nand3_2
X_4688_ _0381_ _0448_ _0449_ VGND VGND VPWR VPWR _0450_ sky130_fd_sc_hd__and3b_1
XFILLER_107_538 VPWR VGND VPWR VGND sky130_ef_sc_hd__decap_12
XFILLER_107_505 VGND VGND VPWR VPWR sky130_fd_sc_hd__decap_3
X_3708_ _1495_ _1583_ VGND VGND VPWR VPWR _2909_ sky130_fd_sc_hd__nand2_1
X_3639_ net226 net406 VGND VGND VPWR VPWR _2842_ sky130_fd_sc_hd__and2_1
X_6427_ _2310_ _2311_ _2110_ _2157_ VGND VGND VPWR VPWR _2315_ sky130_fd_sc_hd__o211a_1
X_6358_ _2229_ _2238_ VGND VGND VPWR VPWR _2239_ sky130_fd_sc_hd__and2_1
X_5309_ _0986_ _0988_ _1091_ _1093_ VGND VGND VPWR VPWR _1095_ sky130_fd_sc_hd__a211o_1
XFILLER_0_337 VGND VGND VPWR VPWR sky130_fd_sc_hd__decap_4
XFILLER_88_477 VPWR VGND VPWR VGND sky130_ef_sc_hd__decap_12
X_6289_ _2001_ _2003_ _2162_ _2163_ VGND VGND VPWR VPWR _2164_ sky130_fd_sc_hd__a211oi_1
XTAP_TAPCELL_ROW_110_1571 VGND VPWR sky130_fd_sc_hd__tapvpwrvgnd_1
XFILLER_102_265 VPWR VGND VPWR VGND sky130_ef_sc_hd__decap_12
XFILLER_84_15 VPWR VGND VPWR VGND sky130_ef_sc_hd__decap_12
XFILLER_69_691 VGND VGND VPWR VPWR sky130_fd_sc_hd__fill_1
XFILLER_16_216 VPWR VGND VPWR VGND sky130_ef_sc_hd__decap_12
XFILLER_31_208 VPWR VGND VPWR VGND sky130_ef_sc_hd__decap_12
XTAP_TAPCELL_ROW_14_417 VGND VPWR sky130_fd_sc_hd__tapvpwrvgnd_1
XFILLER_12_433 VPWR VGND VPWR VGND sky130_ef_sc_hd__decap_12
XTAP_TAPCELL_ROW_42_759 VGND VPWR sky130_fd_sc_hd__tapvpwrvgnd_1
XFILLER_4_643 VGND VGND VPWR VPWR sky130_fd_sc_hd__fill_1
XFILLER_3_153 VGND VGND VPWR VPWR sky130_fd_sc_hd__decap_3
XFILLER_58_93 VGND VGND VPWR VPWR sky130_fd_sc_hd__decap_3
XFILLER_81_119 VGND VGND VPWR VPWR sky130_fd_sc_hd__fill_1
XFILLER_74_70 VGND VGND VPWR VPWR sky130_fd_sc_hd__fill_1
XFILLER_62_333 VGND VGND VPWR VPWR sky130_fd_sc_hd__decap_3
X_3990_ net153 net226 _2695_ _3178_ _1550_ VGND VGND VPWR VPWR _3179_ sky130_fd_sc_hd__a311o_1
XFILLER_62_377 VPWR VGND VPWR VGND sky130_ef_sc_hd__decap_12
XFILLER_15_260 VGND VGND VPWR VPWR sky130_fd_sc_hd__decap_4
X_5660_ _1470_ _1476_ VGND VGND VPWR VPWR _1477_ sky130_fd_sc_hd__xnor2_1
X_4611_ net401 net209 net204 net407 VGND VGND VPWR VPWR _0374_ sky130_fd_sc_hd__a22o_1
X_5591_ _1400_ _1401_ VGND VGND VPWR VPWR _1402_ sky130_fd_sc_hd__xnor2_1
X_4542_ net291 net362 _0304_ _0305_ VGND VGND VPWR VPWR _0306_ sky130_fd_sc_hd__nand4_1
X_4473_ net287 net377 _0208_ _0206_ VGND VGND VPWR VPWR _0238_ sky130_fd_sc_hd__a31o_1
Xmax_cap112 net113 VGND VGND VPWR VPWR net112 sky130_fd_sc_hd__buf_1
X_6212_ net174 net336 _1908_ _1910_ VGND VGND VPWR VPWR _2079_ sky130_fd_sc_hd__a31o_1
X_3424_ net301 VGND VGND VPWR VPWR _0972_ sky130_fd_sc_hd__inv_2
XPHY_EDGE_ROW_115_Right_115 VGND VGND VPWR VPWR sky130_fd_sc_hd__decap_3
XFILLER_97_241 VGND VGND VPWR VPWR sky130_fd_sc_hd__fill_1
X_6143_ _2001_ _2002_ _1840_ _1842_ VGND VGND VPWR VPWR _2004_ sky130_fd_sc_hd__a211o_1
XFILLER_57_116 VGND VGND VPWR VPWR sky130_fd_sc_hd__decap_6
X_6074_ _1925_ _1926_ _1921_ VGND VGND VPWR VPWR _1928_ sky130_fd_sc_hd__a21o_1
X_5025_ _0782_ _0783_ _0703_ VGND VGND VPWR VPWR _0785_ sky130_fd_sc_hd__a21o_1
XFILLER_26_503 VGND VGND VPWR VPWR sky130_fd_sc_hd__fill_2
XFILLER_38_363 VGND VGND VPWR VPWR sky130_fd_sc_hd__fill_1
XFILLER_54_29 VPWR VGND VPWR VGND sky130_ef_sc_hd__decap_12
XFILLER_81_653 VPWR VGND VPWR VGND sky130_ef_sc_hd__decap_12
XFILLER_80_141 VGND VGND VPWR VPWR sky130_fd_sc_hd__decap_6
XFILLER_26_569 VGND VGND VPWR VPWR sky130_fd_sc_hd__fill_1
X_5927_ _1766_ _1767_ VGND VGND VPWR VPWR _1769_ sky130_fd_sc_hd__nand2_1
XFILLER_34_580 VGND VGND VPWR VPWR sky130_fd_sc_hd__fill_1
X_5858_ _1555_ _1557_ _1691_ _1693_ VGND VGND VPWR VPWR _1694_ sky130_fd_sc_hd__o211ai_4
X_4809_ _0491_ _0493_ _0492_ VGND VGND VPWR VPWR _0569_ sky130_fd_sc_hd__a21bo_1
XPHY_EDGE_ROW_17_Right_17 VGND VGND VPWR VPWR sky130_fd_sc_hd__decap_3
X_5789_ net172 net192 VGND VGND VPWR VPWR _1618_ sky130_fd_sc_hd__nand2_1
XFILLER_107_335 VGND VGND VPWR VPWR sky130_fd_sc_hd__fill_1
XFILLER_107_324 VGND VGND VPWR VPWR sky130_fd_sc_hd__fill_2
XFILLER_79_15 VPWR VGND VPWR VGND sky130_ef_sc_hd__decap_12
XTAP_TAPCELL_ROW_112_1600 VGND VPWR sky130_fd_sc_hd__tapvpwrvgnd_1
XFILLER_115_390 VGND VGND VPWR VPWR sky130_fd_sc_hd__fill_2
XFILLER_0_123 VGND VGND VPWR VPWR sky130_fd_sc_hd__fill_1
XFILLER_103_585 VPWR VGND VPWR VGND sky130_ef_sc_hd__decap_12
XFILLER_95_47 VGND VGND VPWR VPWR sky130_fd_sc_hd__fill_1
XFILLER_76_403 VPWR VGND VPWR VGND sky130_ef_sc_hd__decap_12
XFILLER_0_167 VGND VGND VPWR VPWR sky130_fd_sc_hd__fill_1
XFILLER_0_156 VGND VGND VPWR VPWR sky130_fd_sc_hd__decap_3
XPHY_EDGE_ROW_26_Right_26 VGND VGND VPWR VPWR sky130_fd_sc_hd__decap_3
XFILLER_48_105 VGND VGND VPWR VPWR sky130_fd_sc_hd__decap_8
XFILLER_49_617 VPWR VGND VPWR VGND sky130_ef_sc_hd__decap_12
XFILLER_28_41 VPWR VGND VPWR VGND sky130_ef_sc_hd__decap_12
XFILLER_48_138 VGND VGND VPWR VPWR sky130_fd_sc_hd__fill_2
XFILLER_76_469 VGND VGND VPWR VPWR sky130_fd_sc_hd__decap_6
XTAP_TAPCELL_ROW_47_818 VGND VPWR sky130_fd_sc_hd__tapvpwrvgnd_1
XFILLER_28_85 VPWR VGND VPWR VGND sky130_ef_sc_hd__decap_12
XTAP_TAPCELL_ROW_63_1009 VGND VPWR sky130_fd_sc_hd__tapvpwrvgnd_1
XTAP_TAPCELL_ROW_27_575 VGND VPWR sky130_fd_sc_hd__tapvpwrvgnd_1
XFILLER_44_377 VPWR VGND VPWR VGND sky130_ef_sc_hd__decap_12
XPHY_EDGE_ROW_35_Right_35 VGND VGND VPWR VPWR sky130_fd_sc_hd__decap_3
XFILLER_74_9 VPWR VGND VPWR VGND sky130_ef_sc_hd__decap_12
XFILLER_8_234 VGND VGND VPWR VPWR sky130_fd_sc_hd__fill_1
XTAP_TAPCELL_ROW_74_1138 VGND VPWR sky130_fd_sc_hd__tapvpwrvgnd_1
XFILLER_113_349 VPWR VGND VPWR VGND sky130_ef_sc_hd__decap_12
XPHY_EDGE_ROW_44_Right_44 VGND VGND VPWR VPWR sky130_fd_sc_hd__decap_3
XFILLER_85_80 VGND VGND VPWR VPWR sky130_fd_sc_hd__decap_4
XFILLER_63_664 VGND VGND VPWR VPWR sky130_fd_sc_hd__decap_8
XFILLER_62_141 VGND VGND VPWR VPWR sky130_fd_sc_hd__decap_8
X_6830_ net171 net316 VGND VGND VPWR VPWR _2754_ sky130_fd_sc_hd__nand2_1
XTAP_TAPCELL_ROW_85_1267 VGND VPWR sky130_fd_sc_hd__tapvpwrvgnd_1
X_6761_ _2674_ _2675_ _2676_ _2677_ VGND VGND VPWR VPWR _2678_ sky130_fd_sc_hd__and4_1
XPHY_EDGE_ROW_53_Right_53 VGND VGND VPWR VPWR sky130_fd_sc_hd__decap_3
XFILLER_50_325 VGND VGND VPWR VPWR sky130_fd_sc_hd__fill_1
XFILLER_50_336 VGND VGND VPWR VPWR sky130_fd_sc_hd__decap_8
X_5712_ _1532_ _1533_ VGND VGND VPWR VPWR _1534_ sky130_fd_sc_hd__and2_1
X_3973_ _3160_ _3161_ VGND VGND VPWR VPWR _3162_ sky130_fd_sc_hd__and2_2
XFILLER_31_561 VGND VGND VPWR VPWR sky130_fd_sc_hd__decap_8
X_6692_ net234 net222 net435 net428 VGND VGND VPWR VPWR _2603_ sky130_fd_sc_hd__and4_1
X_5643_ _1457_ _1458_ _1455_ VGND VGND VPWR VPWR _1459_ sky130_fd_sc_hd__a21oi_1
XFILLER_31_583 VGND VGND VPWR VPWR sky130_fd_sc_hd__decap_8
X_5574_ _1381_ _1382_ VGND VGND VPWR VPWR _1383_ sky130_fd_sc_hd__xor2_1
X_4525_ _0250_ _0253_ VGND VGND VPWR VPWR _0289_ sky130_fd_sc_hd__nand2_1
X_4456_ _0175_ _0220_ _0221_ VGND VGND VPWR VPWR _0222_ sky130_fd_sc_hd__and3_1
XFILLER_104_316 VPWR VGND VPWR VGND sky130_ef_sc_hd__decap_12
XPHY_EDGE_ROW_62_Right_62 VGND VGND VPWR VPWR sky130_fd_sc_hd__decap_3
X_4387_ net455 net208 net201 net472 VGND VGND VPWR VPWR _0154_ sky130_fd_sc_hd__a22oi_1
X_3407_ net245 VGND VGND VPWR VPWR _0787_ sky130_fd_sc_hd__inv_2
X_6126_ _1981_ _1983_ _1827_ _1829_ VGND VGND VPWR VPWR _1985_ sky130_fd_sc_hd__o211ai_2
XFILLER_105_57 VGND VGND VPWR VPWR sky130_fd_sc_hd__decap_8
XFILLER_100_533 VPWR VGND VPWR VGND sky130_ef_sc_hd__decap_12
XFILLER_58_469 VGND VGND VPWR VPWR sky130_fd_sc_hd__decap_6
X_6057_ net218 net329 _3048_ VGND VGND VPWR VPWR _1910_ sky130_fd_sc_hd__and3_1
X_5008_ _0762_ _0763_ _0672_ _0674_ VGND VGND VPWR VPWR _0767_ sky130_fd_sc_hd__a211o_1
XFILLER_26_300 VGND VGND VPWR VPWR sky130_fd_sc_hd__decap_8
XFILLER_38_171 VPWR VGND VPWR VGND sky130_ef_sc_hd__decap_12
XFILLER_54_642 VGND VGND VPWR VPWR sky130_fd_sc_hd__fill_2
XFILLER_26_333 VPWR VGND VPWR VGND sky130_ef_sc_hd__decap_12
XFILLER_26_355 VGND VGND VPWR VPWR sky130_fd_sc_hd__decap_8
XFILLER_81_27 VPWR VGND VPWR VGND sky130_ef_sc_hd__decap_12
XPHY_EDGE_ROW_71_Right_71 VGND VGND VPWR VPWR sky130_fd_sc_hd__decap_3
XFILLER_14_528 VGND VGND VPWR VPWR sky130_fd_sc_hd__decap_4
XFILLER_26_377 VGND VGND VPWR VPWR sky130_fd_sc_hd__decap_8
XFILLER_26_388 VPWR VGND VPWR VGND sky130_ef_sc_hd__decap_12
XFILLER_53_174 VGND VGND VPWR VPWR sky130_fd_sc_hd__fill_2
XTAP_TAPCELL_ROW_24_534 VGND VPWR sky130_fd_sc_hd__tapvpwrvgnd_1
XTAP_TAPCELL_ROW_24_545 VGND VPWR sky130_fd_sc_hd__tapvpwrvgnd_1
XFILLER_41_325 VGND VGND VPWR VPWR sky130_fd_sc_hd__fill_1
XFILLER_53_196 VGND VGND VPWR VPWR sky130_fd_sc_hd__decap_4
XTAP_TAPCELL_ROW_52_876 VGND VPWR sky130_fd_sc_hd__tapvpwrvgnd_1
XFILLER_14_65 VPWR VGND VPWR VGND sky130_ef_sc_hd__decap_12
XFILLER_5_237 VGND VGND VPWR VPWR sky130_fd_sc_hd__fill_1
XPHY_EDGE_ROW_15_Left_132 VGND VGND VPWR VPWR sky130_fd_sc_hd__decap_3
XFILLER_107_154 VGND VGND VPWR VPWR sky130_fd_sc_hd__decap_8
XPHY_EDGE_ROW_80_Right_80 VGND VGND VPWR VPWR sky130_fd_sc_hd__decap_3
XFILLER_30_53 VPWR VGND VPWR VGND sky130_ef_sc_hd__decap_12
XFILLER_30_97 VPWR VGND VPWR VGND sky130_ef_sc_hd__decap_12
XFILLER_89_561 VPWR VGND VPWR VGND sky130_ef_sc_hd__decap_12
XFILLER_39_51 VGND VGND VPWR VPWR sky130_fd_sc_hd__decap_4
XFILLER_49_414 VPWR VGND VPWR VGND sky130_ef_sc_hd__decap_12
XFILLER_103_393 VPWR VGND VPWR VGND sky130_ef_sc_hd__decap_12
XFILLER_49_447 VGND VGND VPWR VPWR sky130_fd_sc_hd__fill_1
XFILLER_91_225 VPWR VGND VPWR VGND sky130_ef_sc_hd__decap_12
XPHY_EDGE_ROW_24_Left_141 VGND VGND VPWR VPWR sky130_fd_sc_hd__decap_3
XFILLER_29_193 VPWR VGND VPWR VGND sky130_ef_sc_hd__decap_12
XFILLER_44_130 VGND VGND VPWR VPWR sky130_fd_sc_hd__fill_1
XFILLER_45_653 VPWR VGND VPWR VGND sky130_ef_sc_hd__decap_12
XFILLER_44_174 VGND VGND VPWR VPWR sky130_fd_sc_hd__decap_3
XFILLER_60_645 VPWR VGND VPWR VGND sky130_ef_sc_hd__decap_12
XFILLER_60_689 VGND VGND VPWR VPWR sky130_fd_sc_hd__decap_3
XFILLER_13_561 VPWR VGND VPWR VGND sky130_ef_sc_hd__decap_12
XFILLER_9_543 VPWR VGND VPWR VGND sky130_ef_sc_hd__decap_12
XPHY_EDGE_ROW_33_Left_150 VGND VGND VPWR VPWR sky130_fd_sc_hd__decap_3
XFILLER_114_625 VPWR VGND VPWR VGND sky130_ef_sc_hd__decap_12
XFILLER_113_113 VPWR VGND VPWR VGND sky130_ef_sc_hd__decap_12
X_4310_ net286 net414 VGND VGND VPWR VPWR _0080_ sky130_fd_sc_hd__nand2_1
X_5290_ _1058_ _1072_ VGND VGND VPWR VPWR _1074_ sky130_fd_sc_hd__or2_1
XFILLER_114_669 VPWR VGND VPWR VGND sky130_ef_sc_hd__decap_12
X_4241_ net124 _0016_ _0013_ net144 VGND VGND VPWR VPWR _0017_ sky130_fd_sc_hd__a211o_1
XFILLER_67_200 VGND VGND VPWR VPWR sky130_fd_sc_hd__decap_8
XFILLER_67_222 VGND VGND VPWR VPWR sky130_fd_sc_hd__fill_2
X_4172_ net428 net52 VGND VGND VPWR VPWR _3352_ sky130_fd_sc_hd__nor2_1
XFILLER_95_597 VPWR VGND VPWR VGND sky130_ef_sc_hd__decap_12
XFILLER_55_417 VPWR VGND VPWR VGND sky130_ef_sc_hd__decap_12
XFILLER_63_461 VPWR VGND VPWR VGND sky130_ef_sc_hd__decap_12
X_6813_ net367 net266 VGND VGND VPWR VPWR _2735_ sky130_fd_sc_hd__nand2_1
XFILLER_50_111 VGND VGND VPWR VPWR sky130_fd_sc_hd__decap_4
X_6744_ _2655_ _2656_ _2657_ VGND VGND VPWR VPWR _2660_ sky130_fd_sc_hd__o21a_1
X_3956_ _3122_ _3144_ VGND VGND VPWR VPWR _3146_ sky130_fd_sc_hd__nor2_1
X_6675_ _2582_ _2583_ VGND VGND VPWR VPWR _2584_ sky130_fd_sc_hd__and2b_1
XTAP_TAPCELL_ROW_21_504 VGND VPWR sky130_fd_sc_hd__tapvpwrvgnd_1
XTAP_TAPCELL_ROW_98_1425 VGND VPWR sky130_fd_sc_hd__tapvpwrvgnd_1
X_3887_ net324 net261 VGND VGND VPWR VPWR _3080_ sky130_fd_sc_hd__and2b_1
X_5626_ _1378_ _1379_ _1437_ _1438_ VGND VGND VPWR VPWR _1440_ sky130_fd_sc_hd__a22oi_2
X_5557_ _1355_ _1361_ _1362_ VGND VGND VPWR VPWR _1365_ sky130_fd_sc_hd__nand3_2
X_4508_ _0271_ _0272_ VGND VGND VPWR VPWR _0273_ sky130_fd_sc_hd__nand2_1
XFILLER_104_113 VGND VGND VPWR VPWR sky130_fd_sc_hd__fill_1
X_5488_ _1284_ _1286_ _1287_ VGND VGND VPWR VPWR _1290_ sky130_fd_sc_hd__a21o_1
X_4439_ net249 net398 _0163_ _2842_ _2805_ VGND VGND VPWR VPWR _0205_ sky130_fd_sc_hd__a32o_1
XFILLER_104_157 VGND VGND VPWR VPWR sky130_fd_sc_hd__fill_1
XFILLER_113_691 VGND VGND VPWR VPWR sky130_fd_sc_hd__fill_1
XFILLER_76_27 VGND VGND VPWR VPWR sky130_fd_sc_hd__fill_1
X_6109_ _1965_ _1966_ VGND VGND VPWR VPWR _1967_ sky130_fd_sc_hd__and2_1
XFILLER_73_214 VGND VGND VPWR VPWR sky130_fd_sc_hd__fill_2
XTAP_TAPCELL_ROW_57_935 VGND VPWR sky130_fd_sc_hd__tapvpwrvgnd_1
XTAP_TAPCELL_ROW_29_604 VGND VPWR sky130_fd_sc_hd__tapvpwrvgnd_1
XFILLER_46_417 VGND VGND VPWR VPWR sky130_fd_sc_hd__decap_3
XTAP_TAPCELL_ROW_107_1532 VGND VPWR sky130_fd_sc_hd__tapvpwrvgnd_1
XFILLER_92_15 VPWR VGND VPWR VGND sky130_ef_sc_hd__decap_12
XFILLER_27_653 VPWR VGND VPWR VGND sky130_ef_sc_hd__decap_12
XTAP_TAPCELL_ROW_1_262 VGND VPWR sky130_fd_sc_hd__tapvpwrvgnd_1
XFILLER_26_141 VGND VGND VPWR VPWR sky130_fd_sc_hd__decap_8
XFILLER_26_174 VPWR VGND VPWR VGND sky130_ef_sc_hd__decap_12
XTAP_TAPCELL_ROW_37_692 VGND VPWR sky130_fd_sc_hd__tapvpwrvgnd_1
XFILLER_42_645 VPWR VGND VPWR VGND sky130_ef_sc_hd__decap_12
XFILLER_41_166 VGND VGND VPWR VPWR sky130_fd_sc_hd__fill_2
XFILLER_42_689 VGND VGND VPWR VPWR sky130_fd_sc_hd__decap_3
XFILLER_41_177 VGND VGND VPWR VPWR sky130_fd_sc_hd__decap_3
XFILLER_6_557 VPWR VGND VPWR VGND sky130_ef_sc_hd__decap_12
XTAP_TAPCELL_ROW_71_1108 VGND VPWR sky130_fd_sc_hd__tapvpwrvgnd_1
XFILLER_111_617 VPWR VGND VPWR VGND sky130_ef_sc_hd__decap_12
XFILLER_96_328 VGND VGND VPWR VPWR sky130_fd_sc_hd__decap_8
XTAP_TAPCELL_ROW_9_362 VGND VPWR sky130_fd_sc_hd__tapvpwrvgnd_1
XFILLER_49_266 VPWR VGND VPWR VGND sky130_ef_sc_hd__decap_12
XFILLER_37_439 VGND VGND VPWR VPWR sky130_fd_sc_hd__fill_1
XFILLER_92_556 VGND VGND VPWR VPWR sky130_fd_sc_hd__decap_6
XFILLER_92_545 VGND VGND VPWR VPWR sky130_fd_sc_hd__decap_4
XFILLER_92_589 VPWR VGND VPWR VGND sky130_ef_sc_hd__decap_12
XTAP_TAPCELL_ROW_82_1237 VGND VPWR sky130_fd_sc_hd__tapvpwrvgnd_1
X_4790_ net458 net424 net334 net327 VGND VGND VPWR VPWR _0550_ sky130_fd_sc_hd__nand4_1
XFILLER_82_81 VGND VGND VPWR VPWR sky130_fd_sc_hd__decap_3
X_3810_ _3001_ _3003_ VGND VGND VPWR VPWR _3006_ sky130_fd_sc_hd__or2_1
XFILLER_60_442 VGND VGND VPWR VPWR sky130_fd_sc_hd__fill_1
XFILLER_32_155 VGND VGND VPWR VPWR sky130_fd_sc_hd__decap_3
X_3741_ net153 net121 _2938_ _2940_ VGND VGND VPWR VPWR _2941_ sky130_fd_sc_hd__a31o_1
XANTENNA_18 net29 VGND VGND VPWR VPWR sky130_fd_sc_hd__diode_2
XANTENNA_29 net333 VGND VGND VPWR VPWR sky130_fd_sc_hd__diode_2
X_3672_ _2849_ _2873_ VGND VGND VPWR VPWR _2874_ sky130_fd_sc_hd__nor2_1
X_6460_ _2174_ _2178_ _2349_ VGND VGND VPWR VPWR _2350_ sky130_fd_sc_hd__o21ai_1
X_5411_ _1204_ _1205_ VGND VGND VPWR VPWR _1206_ sky130_fd_sc_hd__or2_1
X_6391_ net281 net20 _2273_ VGND VGND VPWR VPWR _2275_ sky130_fd_sc_hd__a21o_1
XFILLER_99_111 VGND VGND VPWR VPWR sky130_fd_sc_hd__fill_1
XFILLER_99_100 VGND VGND VPWR VPWR sky130_fd_sc_hd__fill_1
Xoutput103 net103 VGND VGND VPWR VPWR return_port[4] sky130_fd_sc_hd__clkbuf_4
X_5342_ _1118_ _1128_ _1129_ VGND VGND VPWR VPWR _1130_ sky130_fd_sc_hd__and3_2
XFILLER_114_433 VPWR VGND VPWR VGND sky130_ef_sc_hd__decap_12
XTAP_TAPCELL_ROW_93_1366 VGND VPWR sky130_fd_sc_hd__tapvpwrvgnd_1
XFILLER_114_477 VPWR VGND VPWR VGND sky130_ef_sc_hd__decap_12
XFILLER_99_166 VGND VGND VPWR VPWR sky130_fd_sc_hd__fill_2
XFILLER_87_317 VPWR VGND VPWR VGND sky130_ef_sc_hd__decap_12
X_5273_ _1052_ _1053_ _1054_ VGND VGND VPWR VPWR _1055_ sky130_fd_sc_hd__and3_1
XFILLER_99_188 VGND VGND VPWR VPWR sky130_fd_sc_hd__fill_1
X_4224_ net131 _3393_ _3401_ VGND VGND VPWR VPWR _3402_ sky130_fd_sc_hd__a21oi_1
XFILLER_101_149 VPWR VGND VPWR VGND sky130_ef_sc_hd__decap_12
XFILLER_68_553 VPWR VGND VPWR VGND sky130_ef_sc_hd__decap_12
X_4155_ _3321_ _3334_ _3335_ VGND VGND VPWR VPWR _3336_ sky130_fd_sc_hd__or3_1
XFILLER_68_586 VGND VGND VPWR VPWR sky130_fd_sc_hd__fill_2
XFILLER_55_214 VGND VGND VPWR VPWR sky130_fd_sc_hd__decap_6
XFILLER_28_417 VGND VGND VPWR VPWR sky130_fd_sc_hd__decap_3
XFILLER_46_19 VGND VGND VPWR VPWR sky130_fd_sc_hd__decap_8
X_4086_ _3245_ _3249_ _1887_ VGND VGND VPWR VPWR _3270_ sky130_fd_sc_hd__a21oi_1
XTAP_TAPCELL_ROW_54_905 VGND VPWR sky130_fd_sc_hd__tapvpwrvgnd_1
XFILLER_24_601 VPWR VGND VPWR VGND sky130_ef_sc_hd__decap_12
XFILLER_24_645 VPWR VGND VPWR VGND sky130_ef_sc_hd__decap_12
XFILLER_24_689 VGND VGND VPWR VPWR sky130_fd_sc_hd__decap_3
XFILLER_51_453 VPWR VGND VPWR VGND sky130_ef_sc_hd__decap_12
XTAP_TAPCELL_ROW_102_1473 VGND VPWR sky130_fd_sc_hd__tapvpwrvgnd_1
X_4988_ _2335_ _0745_ VGND VGND VPWR VPWR _0746_ sky130_fd_sc_hd__nand2b_1
XTAP_TAPCELL_ROW_62_993 VGND VPWR sky130_fd_sc_hd__tapvpwrvgnd_1
XFILLER_23_166 VGND VGND VPWR VPWR sky130_fd_sc_hd__fill_2
XTAP_TAPCELL_ROW_34_662 VGND VPWR sky130_fd_sc_hd__tapvpwrvgnd_1
XFILLER_51_497 VGND VGND VPWR VPWR sky130_fd_sc_hd__decap_6
X_3939_ _3114_ _3128_ net123 VGND VGND VPWR VPWR _3130_ sky130_fd_sc_hd__o21a_1
X_6727_ _2601_ _2639_ VGND VGND VPWR VPWR _2642_ sky130_fd_sc_hd__nor2_1
X_6658_ net460 net336 VGND VGND VPWR VPWR _2566_ sky130_fd_sc_hd__nand2_1
XFILLER_109_249 VPWR VGND VPWR VGND sky130_ef_sc_hd__decap_12
X_5609_ _1420_ _1421_ _1413_ VGND VGND VPWR VPWR _1422_ sky130_fd_sc_hd__a21o_1
XFILLER_11_55 VGND VGND VPWR VPWR sky130_fd_sc_hd__fill_1
XFILLER_3_505 VPWR VGND VPWR VGND sky130_ef_sc_hd__decap_12
X_6589_ _2489_ _2490_ VGND VGND VPWR VPWR _2491_ sky130_fd_sc_hd__or2_1
XFILLER_87_15 VGND VGND VPWR VPWR sky130_fd_sc_hd__decap_3
XFILLER_11_77 VPWR VGND VPWR VGND sky130_ef_sc_hd__decap_12
XFILLER_105_477 VGND VGND VPWR VPWR sky130_fd_sc_hd__decap_3
XTAP_TAPCELL_ROW_6_321 VGND VPWR sky130_fd_sc_hd__tapvpwrvgnd_1
Xfanout330 net333 VGND VGND VPWR VPWR net330 sky130_fd_sc_hd__buf_2
Xfanout341 net343 VGND VGND VPWR VPWR net341 sky130_fd_sc_hd__buf_2
Xfanout363 net364 VGND VGND VPWR VPWR net363 sky130_fd_sc_hd__buf_2
Xfanout352 net353 VGND VGND VPWR VPWR net352 sky130_fd_sc_hd__clkbuf_2
Xfanout374 net376 VGND VGND VPWR VPWR net374 sky130_fd_sc_hd__clkbuf_4
Xfanout385 net387 VGND VGND VPWR VPWR net385 sky130_fd_sc_hd__buf_2
Xfanout396 net397 VGND VGND VPWR VPWR net396 sky130_fd_sc_hd__buf_2
XFILLER_46_258 VGND VGND VPWR VPWR sky130_fd_sc_hd__decap_4
XFILLER_74_589 VPWR VGND VPWR VGND sky130_ef_sc_hd__decap_12
XFILLER_74_578 VGND VGND VPWR VPWR sky130_fd_sc_hd__decap_8
XFILLER_36_41 VPWR VGND VPWR VGND sky130_ef_sc_hd__decap_12
XTAP_TAPCELL_ROW_68_1070 VGND VPWR sky130_fd_sc_hd__tapvpwrvgnd_1
XFILLER_42_464 VGND VGND VPWR VPWR sky130_fd_sc_hd__decap_4
XFILLER_42_475 VGND VGND VPWR VPWR sky130_fd_sc_hd__fill_1
Xinput27 a[4] VGND VGND VPWR VPWR net27 sky130_fd_sc_hd__clkbuf_2
Xinput16 a[23] VGND VGND VPWR VPWR net16 sky130_fd_sc_hd__clkbuf_2
XFILLER_6_332 VGND VGND VPWR VPWR sky130_fd_sc_hd__decap_8
Xinput49 b[24] VGND VGND VPWR VPWR net49 sky130_fd_sc_hd__clkbuf_1
Xinput38 b[14] VGND VGND VPWR VPWR net38 sky130_fd_sc_hd__buf_1
XFILLER_6_365 VGND VGND VPWR VPWR sky130_fd_sc_hd__decap_4
XFILLER_97_615 VGND VGND VPWR VPWR sky130_fd_sc_hd__fill_1
XFILLER_69_317 VGND VGND VPWR VPWR sky130_fd_sc_hd__decap_4
XFILLER_111_447 VGND VGND VPWR VPWR sky130_fd_sc_hd__fill_1
XFILLER_84_309 VGND VGND VPWR VPWR sky130_fd_sc_hd__decap_8
XFILLER_37_225 VPWR VGND VPWR VGND sky130_ef_sc_hd__decap_12
XFILLER_65_578 VGND VGND VPWR VPWR sky130_fd_sc_hd__decap_8
X_5960_ net247 net441 VGND VGND VPWR VPWR _1805_ sky130_fd_sc_hd__nand2_1
XFILLER_52_217 VGND VGND VPWR VPWR sky130_fd_sc_hd__fill_2
X_4911_ _0662_ _0668_ _0669_ VGND VGND VPWR VPWR _0670_ sky130_fd_sc_hd__nand3_2
X_5891_ _1727_ _1728_ net419 net267 VGND VGND VPWR VPWR _1729_ sky130_fd_sc_hd__and4bb_1
XFILLER_33_442 VGND VGND VPWR VPWR sky130_fd_sc_hd__decap_6
X_4842_ _0561_ _0600_ _0601_ VGND VGND VPWR VPWR _0602_ sky130_fd_sc_hd__and3_1
XFILLER_20_114 VGND VGND VPWR VPWR sky130_fd_sc_hd__decap_6
X_4773_ _0531_ _0532_ _0459_ _0462_ VGND VGND VPWR VPWR _0534_ sky130_fd_sc_hd__a211oi_1
XTAP_TAPCELL_ROW_31_621 VGND VPWR sky130_fd_sc_hd__tapvpwrvgnd_1
X_3724_ _2871_ _2895_ _2897_ _2893_ VGND VGND VPWR VPWR _2924_ sky130_fd_sc_hd__a31o_1
X_6512_ _2405_ _2406_ VGND VGND VPWR VPWR _2407_ sky130_fd_sc_hd__nor2_1
X_3655_ _0787_ _1506_ VGND VGND VPWR VPWR _2858_ sky130_fd_sc_hd__and2_1
XFILLER_9_192 VGND VGND VPWR VPWR sky130_fd_sc_hd__decap_8
X_6443_ _2013_ _2330_ _2331_ VGND VGND VPWR VPWR _2332_ sky130_fd_sc_hd__a21oi_1
XFILLER_106_208 VPWR VGND VPWR VGND sky130_ef_sc_hd__decap_12
X_3586_ _2717_ _2728_ VGND VGND VPWR VPWR _2739_ sky130_fd_sc_hd__nor2_2
X_6374_ _2058_ _2060_ _2254_ _2255_ VGND VGND VPWR VPWR _2256_ sky130_fd_sc_hd__a211o_1
X_5325_ _1108_ _1109_ VGND VGND VPWR VPWR _1111_ sky130_fd_sc_hd__xor2_1
XFILLER_88_637 VGND VGND VPWR VPWR sky130_fd_sc_hd__decap_6
X_5256_ _0925_ _0930_ _1034_ _1035_ VGND VGND VPWR VPWR _1036_ sky130_fd_sc_hd__a211oi_4
XFILLER_87_147 VGND VGND VPWR VPWR sky130_fd_sc_hd__decap_8
X_4207_ _3306_ _3385_ net161 VGND VGND VPWR VPWR _3386_ sky130_fd_sc_hd__mux2_1
XFILLER_96_681 VGND VGND VPWR VPWR sky130_fd_sc_hd__decap_8
X_5187_ _0959_ _0960_ VGND VGND VPWR VPWR _0962_ sky130_fd_sc_hd__xnor2_1
XFILLER_28_214 VGND VGND VPWR VPWR sky130_fd_sc_hd__fill_1
XTAP_TAPCELL_ROW_39_721 VGND VPWR sky130_fd_sc_hd__tapvpwrvgnd_1
X_4138_ net438 _0994_ _3300_ _3314_ VGND VGND VPWR VPWR _3320_ sky130_fd_sc_hd__a211oi_1
XFILLER_113_57 VPWR VGND VPWR VGND sky130_ef_sc_hd__decap_12
XFILLER_83_353 VPWR VGND VPWR VGND sky130_ef_sc_hd__decap_12
XFILLER_73_17 VGND VGND VPWR VPWR sky130_fd_sc_hd__fill_1
X_4069_ _3234_ _3247_ _3253_ VGND VGND VPWR VPWR _3254_ sky130_fd_sc_hd__and3_1
XTAP_TAPCELL_ROW_104_1502 VGND VPWR sky130_fd_sc_hd__tapvpwrvgnd_1
XFILLER_43_217 VGND VGND VPWR VPWR sky130_fd_sc_hd__decap_6
XFILLER_36_291 VGND VGND VPWR VPWR sky130_fd_sc_hd__decap_3
XFILLER_12_637 VGND VGND VPWR VPWR sky130_fd_sc_hd__decap_6
XFILLER_24_464 VPWR VGND VPWR VGND sky130_ef_sc_hd__decap_12
XFILLER_11_169 VPWR VGND VPWR VGND sky130_ef_sc_hd__decap_12
XFILLER_20_681 VGND VGND VPWR VPWR sky130_fd_sc_hd__decap_8
XFILLER_22_65 VGND VGND VPWR VPWR sky130_fd_sc_hd__decap_4
XTAP_TAPCELL_ROW_115_1631 VGND VPWR sky130_fd_sc_hd__tapvpwrvgnd_1
XFILLER_3_335 VGND VGND VPWR VPWR sky130_fd_sc_hd__fill_1
XFILLER_105_252 VPWR VGND VPWR VGND sky130_ef_sc_hd__decap_12
XFILLER_79_604 VPWR VGND VPWR VGND sky130_ef_sc_hd__decap_12
XFILLER_0_3 VPWR VGND VPWR VGND sky130_ef_sc_hd__decap_12
Xfanout182 net184 VGND VGND VPWR VPWR net182 sky130_fd_sc_hd__clkbuf_2
Xfanout160 net162 VGND VGND VPWR VPWR net160 sky130_fd_sc_hd__buf_2
Xfanout171 net173 VGND VGND VPWR VPWR net171 sky130_fd_sc_hd__buf_2
XFILLER_19_225 VGND VGND VPWR VPWR sky130_fd_sc_hd__decap_8
XFILLER_19_236 VPWR VGND VPWR VGND sky130_ef_sc_hd__decap_12
Xfanout193 net197 VGND VGND VPWR VPWR net193 sky130_fd_sc_hd__clkbuf_4
XFILLER_63_61 VGND VGND VPWR VPWR sky130_fd_sc_hd__decap_6
XTAP_TAPCELL_ROW_17_459 VGND VPWR sky130_fd_sc_hd__tapvpwrvgnd_1
XFILLER_70_570 VGND VGND VPWR VPWR sky130_fd_sc_hd__fill_2
XFILLER_15_497 VGND VGND VPWR VPWR sky130_fd_sc_hd__decap_6
XPHY_EDGE_ROW_7_Left_124 VGND VGND VPWR VPWR sky130_fd_sc_hd__decap_3
XFILLER_7_641 VPWR VGND VPWR VGND sky130_ef_sc_hd__decap_12
XFILLER_116_517 VPWR VGND VPWR VGND sky130_ef_sc_hd__decap_12
XFILLER_7_685 VGND VGND VPWR VPWR sky130_fd_sc_hd__decap_6
XFILLER_6_162 VPWR VGND VPWR VGND sky130_ef_sc_hd__decap_12
X_3440_ _1113_ _1124_ VGND VGND VPWR VPWR _1146_ sky130_fd_sc_hd__or2_2
X_5110_ _0770_ _0772_ _0876_ _0877_ VGND VGND VPWR VPWR _0878_ sky130_fd_sc_hd__o211ai_4
XTAP_TAPCELL_ROW_90_1336 VGND VPWR sky130_fd_sc_hd__tapvpwrvgnd_1
X_6090_ _1901_ _1902_ _1941_ _1943_ VGND VGND VPWR VPWR _1946_ sky130_fd_sc_hd__a2bb2o_1
XFILLER_33_3 VPWR VGND VPWR VGND sky130_ef_sc_hd__decap_12
X_5041_ net402 net334 net327 net409 VGND VGND VPWR VPWR _0802_ sky130_fd_sc_hd__a22o_1
XFILLER_69_158 VGND VGND VPWR VPWR sky130_fd_sc_hd__decap_8
XFILLER_111_288 VPWR VGND VPWR VGND sky130_ef_sc_hd__decap_12
XFILLER_85_629 VPWR VGND VPWR VGND sky130_ef_sc_hd__decap_12
XFILLER_84_128 VGND VGND VPWR VPWR sky130_fd_sc_hd__fill_2
XFILLER_78_681 VGND VGND VPWR VPWR sky130_fd_sc_hd__decap_8
XFILLER_69_169 VGND VGND VPWR VPWR sky130_fd_sc_hd__decap_8
XFILLER_93_673 VPWR VGND VPWR VGND sky130_ef_sc_hd__decap_12
XFILLER_65_364 VPWR VGND VPWR VGND sky130_ef_sc_hd__decap_12
XFILLER_92_194 VGND VGND VPWR VPWR sky130_fd_sc_hd__fill_2
XFILLER_92_183 VGND VGND VPWR VPWR sky130_fd_sc_hd__decap_3
XFILLER_80_345 VPWR VGND VPWR VGND sky130_ef_sc_hd__decap_12
X_5943_ _1782_ _1783_ _1784_ VGND VGND VPWR VPWR _1786_ sky130_fd_sc_hd__nand3_1
XFILLER_21_412 VGND VGND VPWR VPWR sky130_fd_sc_hd__decap_8
XFILLER_40_209 VGND VGND VPWR VPWR sky130_fd_sc_hd__decap_8
X_5874_ _1571_ _1574_ _1709_ _1710_ VGND VGND VPWR VPWR _1711_ sky130_fd_sc_hd__o211ai_2
X_4825_ net365 net216 _0582_ _0583_ VGND VGND VPWR VPWR _0585_ sky130_fd_sc_hd__nand4_2
X_4756_ _0514_ _0515_ _0417_ VGND VGND VPWR VPWR _0517_ sky130_fd_sc_hd__a21o_1
X_4687_ _0446_ _0447_ _0435_ VGND VGND VPWR VPWR _0449_ sky130_fd_sc_hd__a21o_1
X_3707_ _2509_ _2531_ net246 VGND VGND VPWR VPWR _2908_ sky130_fd_sc_hd__mux2_1
X_3638_ net239 net414 net145 _2817_ _2841_ VGND VGND VPWR VPWR _alu_i0.Datapath_i.fu_alu_33673_33851.out1\[3\]
+ sky130_fd_sc_hd__a311o_1
X_6426_ _2110_ _2157_ _2310_ _2311_ VGND VGND VPWR VPWR _2313_ sky130_fd_sc_hd__a211o_1
XFILLER_115_561 VPWR VGND VPWR VGND sky130_ef_sc_hd__decap_12
X_3569_ net159 _2531_ _2542_ _1495_ VGND VGND VPWR VPWR _2553_ sky130_fd_sc_hd__a22o_1
X_6357_ _2234_ _2235_ VGND VGND VPWR VPWR _2238_ sky130_fd_sc_hd__xnor2_1
X_5308_ _1091_ _1093_ _0986_ _0988_ VGND VGND VPWR VPWR _1094_ sky130_fd_sc_hd__o211a_1
XFILLER_102_222 VPWR VGND VPWR VGND sky130_ef_sc_hd__decap_12
XFILLER_76_607 VPWR VGND VPWR VGND sky130_ef_sc_hd__decap_12
X_6288_ _2159_ _2160_ _1993_ _1996_ VGND VGND VPWR VPWR _2163_ sky130_fd_sc_hd__o211a_1
XTAP_TAPCELL_ROW_110_1572 VGND VPWR sky130_fd_sc_hd__tapvpwrvgnd_1
XFILLER_102_277 VGND VGND VPWR VPWR sky130_fd_sc_hd__decap_3
XFILLER_88_489 VPWR VGND VPWR VGND sky130_ef_sc_hd__decap_12
X_5239_ net262 net207 net200 net313 VGND VGND VPWR VPWR _1018_ sky130_fd_sc_hd__a22o_1
XFILLER_29_512 VGND VGND VPWR VPWR sky130_fd_sc_hd__decap_8
XFILLER_84_27 VGND VGND VPWR VPWR sky130_fd_sc_hd__fill_1
XFILLER_90_109 VGND VGND VPWR VPWR sky130_fd_sc_hd__fill_2
XFILLER_71_323 VGND VGND VPWR VPWR sky130_fd_sc_hd__decap_3
XFILLER_16_228 VPWR VGND VPWR VGND sky130_ef_sc_hd__decap_12
XTAP_TAPCELL_ROW_14_418 VGND VPWR sky130_fd_sc_hd__tapvpwrvgnd_1
XFILLER_12_445 VPWR VGND VPWR VGND sky130_ef_sc_hd__decap_12
XFILLER_98_209 VGND VGND VPWR VPWR sky130_fd_sc_hd__decap_8
XFILLER_3_143 VGND VGND VPWR VPWR sky130_fd_sc_hd__decap_6
XFILLER_94_404 VPWR VGND VPWR VGND sky130_ef_sc_hd__decap_12
XFILLER_58_83 VGND VGND VPWR VPWR sky130_fd_sc_hd__fill_1
XFILLER_75_673 VPWR VGND VPWR VGND sky130_ef_sc_hd__decap_12
XFILLER_74_150 VGND VGND VPWR VPWR sky130_fd_sc_hd__decap_4
XFILLER_90_643 VGND VGND VPWR VPWR sky130_fd_sc_hd__fill_1
XFILLER_62_389 VPWR VGND VPWR VGND sky130_ef_sc_hd__decap_12
XFILLER_15_272 VGND VGND VPWR VPWR sky130_fd_sc_hd__decap_8
XFILLER_30_220 VPWR VGND VPWR VGND sky130_ef_sc_hd__decap_12
X_4610_ net409 net401 net210 net202 VGND VGND VPWR VPWR _0373_ sky130_fd_sc_hd__nand4_1
XFILLER_90_81 VGND VGND VPWR VPWR sky130_fd_sc_hd__decap_3
XFILLER_30_264 VGND VGND VPWR VPWR sky130_fd_sc_hd__fill_1
XFILLER_90_92 VPWR VGND VPWR VGND sky130_ef_sc_hd__decap_12
X_5590_ net219 net192 VGND VGND VPWR VPWR _1401_ sky130_fd_sc_hd__nand2_1
X_4541_ _0300_ _0301_ _0302_ VGND VGND VPWR VPWR _0305_ sky130_fd_sc_hd__a21o_1
X_4472_ _0235_ _0236_ VGND VGND VPWR VPWR _0237_ sky130_fd_sc_hd__nor2_1
Xmax_cap113 _1798_ VGND VGND VPWR VPWR net113 sky130_fd_sc_hd__clkbuf_1
X_3423_ net306 VGND VGND VPWR VPWR _0961_ sky130_fd_sc_hd__inv_2
X_6211_ _2076_ _2077_ VGND VGND VPWR VPWR _2078_ sky130_fd_sc_hd__xnor2_1
X_6142_ _1840_ _1842_ _2001_ _2002_ VGND VGND VPWR VPWR _2003_ sky130_fd_sc_hd__o211ai_4
XFILLER_112_531 VGND VGND VPWR VPWR sky130_fd_sc_hd__fill_1
X_6073_ _1921_ _1925_ _1926_ VGND VGND VPWR VPWR _1927_ sky130_fd_sc_hd__nand3_1
X_5024_ _0703_ _0782_ _0783_ VGND VGND VPWR VPWR _0784_ sky130_fd_sc_hd__nand3_2
XFILLER_38_353 VGND VGND VPWR VPWR sky130_fd_sc_hd__fill_1
XFILLER_81_665 VGND VGND VPWR VPWR sky130_fd_sc_hd__decap_6
XFILLER_53_334 VGND VGND VPWR VPWR sky130_fd_sc_hd__fill_2
X_5926_ net6 net337 _1764_ _1765_ VGND VGND VPWR VPWR _1767_ sky130_fd_sc_hd__a22o_1
XFILLER_70_29 VPWR VGND VPWR VGND sky130_ef_sc_hd__decap_12
XFILLER_70_18 VGND VGND VPWR VPWR sky130_fd_sc_hd__decap_8
X_5857_ _1688_ _1690_ _1551_ _1554_ VGND VGND VPWR VPWR _1693_ sky130_fd_sc_hd__o211ai_2
X_4808_ _0564_ _0565_ _0566_ VGND VGND VPWR VPWR _0568_ sky130_fd_sc_hd__nand3_1
X_5788_ _1614_ _1616_ VGND VGND VPWR VPWR _1617_ sky130_fd_sc_hd__and2b_1
X_4739_ _0490_ _0499_ VGND VGND VPWR VPWR _0500_ sky130_fd_sc_hd__xnor2_1
XFILLER_79_27 VGND VGND VPWR VPWR sky130_fd_sc_hd__decap_8
XTAP_TAPCELL_ROW_112_1601 VGND VPWR sky130_fd_sc_hd__tapvpwrvgnd_1
XFILLER_79_38 VGND VGND VPWR VPWR sky130_fd_sc_hd__decap_8
X_6409_ _2080_ _2082_ _2294_ VGND VGND VPWR VPWR _2295_ sky130_fd_sc_hd__o21a_1
XFILLER_88_231 VPWR VGND VPWR VGND sky130_ef_sc_hd__decap_12
XFILLER_95_15 VPWR VGND VPWR VGND sky130_ef_sc_hd__decap_12
XFILLER_88_253 VPWR VGND VPWR VGND sky130_ef_sc_hd__decap_12
XFILLER_76_415 VGND VGND VPWR VPWR sky130_fd_sc_hd__decap_4
XFILLER_49_629 VPWR VGND VPWR VGND sky130_ef_sc_hd__decap_12
XFILLER_103_597 VPWR VGND VPWR VGND sky130_ef_sc_hd__decap_12
XFILLER_91_407 VPWR VGND VPWR VGND sky130_ef_sc_hd__decap_12
XFILLER_57_673 VPWR VGND VPWR VGND sky130_ef_sc_hd__decap_12
XFILLER_28_53 VPWR VGND VPWR VGND sky130_ef_sc_hd__decap_12
XFILLER_29_353 VGND VGND VPWR VPWR sky130_fd_sc_hd__decap_3
XTAP_TAPCELL_ROW_47_819 VGND VPWR sky130_fd_sc_hd__tapvpwrvgnd_1
XFILLER_28_97 VPWR VGND VPWR VGND sky130_ef_sc_hd__decap_12
XFILLER_29_386 VGND VGND VPWR VPWR sky130_fd_sc_hd__decap_6
XPHY_EDGE_ROW_88_Left_205 VGND VGND VPWR VPWR sky130_fd_sc_hd__decap_3
XFILLER_72_643 VGND VGND VPWR VPWR sky130_fd_sc_hd__fill_1
XFILLER_71_164 VGND VGND VPWR VPWR sky130_fd_sc_hd__decap_4
XTAP_TAPCELL_ROW_27_576 VGND VPWR sky130_fd_sc_hd__tapvpwrvgnd_1
XFILLER_44_41 VPWR VGND VPWR VGND sky130_ef_sc_hd__decap_12
XFILLER_44_389 VPWR VGND VPWR VGND sky130_ef_sc_hd__decap_12
XFILLER_44_85 VGND VGND VPWR VPWR sky130_fd_sc_hd__decap_3
XFILLER_12_253 VGND VGND VPWR VPWR sky130_fd_sc_hd__fill_1
XFILLER_40_595 VPWR VGND VPWR VGND sky130_ef_sc_hd__decap_12
XFILLER_8_268 VPWR VGND VPWR VGND sky130_ef_sc_hd__decap_12
XPHY_EDGE_ROW_97_Left_214 VGND VGND VPWR VPWR sky130_fd_sc_hd__decap_3
XFILLER_99_529 VPWR VGND VPWR VGND sky130_ef_sc_hd__decap_12
XTAP_TAPCELL_ROW_74_1139 VGND VPWR sky130_fd_sc_hd__tapvpwrvgnd_1
XFILLER_5_79 VPWR VGND VPWR VGND sky130_ef_sc_hd__decap_12
XFILLER_5_57 VGND VGND VPWR VPWR sky130_fd_sc_hd__decap_8
XFILLER_69_93 VPWR VGND VPWR VGND sky130_ef_sc_hd__decap_12
XFILLER_39_106 VGND VGND VPWR VPWR sky130_fd_sc_hd__decap_6
XFILLER_0_691 VGND VGND VPWR VPWR sky130_fd_sc_hd__fill_1
XFILLER_47_150 VGND VGND VPWR VPWR sky130_fd_sc_hd__decap_3
XFILLER_35_345 VGND VGND VPWR VPWR sky130_fd_sc_hd__decap_8
XFILLER_90_484 VGND VGND VPWR VPWR sky130_fd_sc_hd__decap_4
XFILLER_90_462 VGND VGND VPWR VPWR sky130_fd_sc_hd__decap_3
XTAP_TAPCELL_ROW_85_1268 VGND VPWR sky130_fd_sc_hd__tapvpwrvgnd_1
XFILLER_23_518 VPWR VGND VPWR VGND sky130_ef_sc_hd__decap_12
X_6760_ net157 _0808_ _0895_ net427 VGND VGND VPWR VPWR _2677_ sky130_fd_sc_hd__or4b_1
XFILLER_62_197 VGND VGND VPWR VPWR sky130_fd_sc_hd__decap_4
X_3972_ net465 net298 VGND VGND VPWR VPWR _3161_ sky130_fd_sc_hd__nand2_1
X_5711_ net247 net450 _1337_ _1338_ net463 VGND VGND VPWR VPWR _1533_ sky130_fd_sc_hd__a32o_1
X_6691_ _0808_ _0885_ _0895_ net157 VGND VGND VPWR VPWR _2602_ sky130_fd_sc_hd__o22a_1
X_5642_ _1206_ _1207_ _1330_ _1331_ VGND VGND VPWR VPWR _1458_ sky130_fd_sc_hd__o31a_1
X_5573_ net420 net275 VGND VGND VPWR VPWR _1382_ sky130_fd_sc_hd__nand2_1
X_4524_ _alu_i0.Datapath_i.reg_0.reg_out1\[9\] net146 _0288_ VGND VGND VPWR VPWR net108
+ sky130_fd_sc_hd__o21a_1
XFILLER_116_166 VGND VGND VPWR VPWR sky130_fd_sc_hd__fill_2
X_4455_ net472 net196 _0217_ _0218_ VGND VGND VPWR VPWR _0221_ sky130_fd_sc_hd__a22o_1
XFILLER_104_328 VPWR VGND VPWR VGND sky130_ef_sc_hd__decap_12
X_4386_ net471 net454 net208 net201 VGND VGND VPWR VPWR _0153_ sky130_fd_sc_hd__and4_1
X_3406_ net67 VGND VGND VPWR VPWR _0776_ sky130_fd_sc_hd__inv_2
XFILLER_112_361 VGND VGND VPWR VPWR sky130_fd_sc_hd__decap_3
XFILLER_58_415 VGND VGND VPWR VPWR sky130_fd_sc_hd__decap_4
X_6125_ _1827_ _1829_ _1981_ _1983_ VGND VGND VPWR VPWR _1984_ sky130_fd_sc_hd__a211o_2
XFILLER_100_545 VPWR VGND VPWR VGND sky130_ef_sc_hd__decap_12
XFILLER_85_223 VGND VGND VPWR VPWR sky130_fd_sc_hd__fill_1
XFILLER_85_267 VGND VGND VPWR VPWR sky130_fd_sc_hd__decap_4
X_6056_ net218 net330 _3048_ VGND VGND VPWR VPWR _1908_ sky130_fd_sc_hd__a21o_1
XFILLER_100_589 VPWR VGND VPWR VGND sky130_ef_sc_hd__decap_12
X_5007_ _0764_ VGND VGND VPWR VPWR _0766_ sky130_fd_sc_hd__inv_2
XFILLER_39_673 VPWR VGND VPWR VGND sky130_ef_sc_hd__decap_12
XFILLER_26_345 VGND VGND VPWR VPWR sky130_fd_sc_hd__decap_4
XFILLER_38_183 VGND VGND VPWR VPWR sky130_fd_sc_hd__decap_3
XFILLER_38_194 VGND VGND VPWR VPWR sky130_fd_sc_hd__fill_2
XFILLER_81_39 VGND VGND VPWR VPWR sky130_fd_sc_hd__decap_6
XTAP_TAPCELL_ROW_24_535 VGND VPWR sky130_fd_sc_hd__tapvpwrvgnd_1
X_6889_ net181 _alu_i0.Datapath_i.fu_alu_33673_33851.out1\[15\] VGND VGND VPWR VPWR
+ _alu_i0.Datapath_i.reg_0.reg_out1\[15\] sky130_fd_sc_hd__dfxtp_1
XTAP_TAPCELL_ROW_52_877 VGND VPWR sky130_fd_sc_hd__tapvpwrvgnd_1
X_5909_ net368 net302 VGND VGND VPWR VPWR _1749_ sky130_fd_sc_hd__nand2_1
XFILLER_22_551 VPWR VGND VPWR VGND sky130_ef_sc_hd__decap_12
XFILLER_14_77 VGND VGND VPWR VPWR sky130_fd_sc_hd__decap_6
XFILLER_108_601 VPWR VGND VPWR VGND sky130_ef_sc_hd__decap_12
XFILLER_108_645 VPWR VGND VPWR VGND sky130_ef_sc_hd__decap_12
XFILLER_30_65 VPWR VGND VPWR VGND sky130_ef_sc_hd__decap_12
XFILLER_108_689 VGND VGND VPWR VPWR sky130_fd_sc_hd__decap_3
XFILLER_100_3 VPWR VGND VPWR VGND sky130_ef_sc_hd__decap_12
XFILLER_1_400 VGND VGND VPWR VPWR sky130_fd_sc_hd__decap_4
XFILLER_1_422 VGND VGND VPWR VPWR sky130_fd_sc_hd__decap_3
XFILLER_1_444 VGND VGND VPWR VPWR sky130_fd_sc_hd__decap_4
XFILLER_110_309 VPWR VGND VPWR VGND sky130_ef_sc_hd__decap_12
XFILLER_89_573 VPWR VGND VPWR VGND sky130_ef_sc_hd__decap_12
XFILLER_89_551 VGND VGND VPWR VPWR sky130_fd_sc_hd__decap_8
XFILLER_49_426 VGND VGND VPWR VPWR sky130_fd_sc_hd__decap_4
XFILLER_76_278 VPWR VGND VPWR VGND sky130_ef_sc_hd__decap_12
XFILLER_29_161 VGND VGND VPWR VPWR sky130_fd_sc_hd__decap_6
XFILLER_91_237 VPWR VGND VPWR VGND sky130_ef_sc_hd__decap_12
XFILLER_17_345 VGND VGND VPWR VPWR sky130_fd_sc_hd__decap_8
XFILLER_55_73 VPWR VGND VPWR VGND sky130_ef_sc_hd__decap_12
XFILLER_45_665 VGND VGND VPWR VPWR sky130_fd_sc_hd__decap_6
XFILLER_60_657 VPWR VGND VPWR VGND sky130_ef_sc_hd__decap_12
XFILLER_44_197 VGND VGND VPWR VPWR sky130_fd_sc_hd__decap_3
XFILLER_71_50 VGND VGND VPWR VPWR sky130_fd_sc_hd__fill_2
XFILLER_13_540 VPWR VGND VPWR VGND sky130_ef_sc_hd__decap_12
XFILLER_13_573 VPWR VGND VPWR VGND sky130_ef_sc_hd__decap_12
XFILLER_9_555 VGND VGND VPWR VPWR sky130_fd_sc_hd__decap_4
XFILLER_114_637 VGND VGND VPWR VPWR sky130_fd_sc_hd__decap_6
XFILLER_113_125 VPWR VGND VPWR VGND sky130_ef_sc_hd__decap_12
XFILLER_99_337 VPWR VGND VPWR VGND sky130_ef_sc_hd__decap_12
X_4240_ _0009_ _0015_ VGND VGND VPWR VPWR _0016_ sky130_fd_sc_hd__xnor2_1
XFILLER_113_169 VPWR VGND VPWR VGND sky130_ef_sc_hd__decap_12
XFILLER_101_309 VGND VGND VPWR VPWR sky130_fd_sc_hd__fill_2
X_4171_ _3350_ VGND VGND VPWR VPWR _3351_ sky130_fd_sc_hd__inv_2
XFILLER_95_554 VGND VGND VPWR VPWR sky130_fd_sc_hd__decap_6
XFILLER_55_429 VPWR VGND VPWR VGND sky130_ef_sc_hd__decap_12
XFILLER_36_621 VPWR VGND VPWR VGND sky130_ef_sc_hd__decap_12
XFILLER_82_248 VGND VGND VPWR VPWR sky130_fd_sc_hd__decap_4
XFILLER_63_473 VGND VGND VPWR VPWR sky130_fd_sc_hd__decap_4
X_6812_ net374 net266 _2514_ _2513_ VGND VGND VPWR VPWR _2734_ sky130_fd_sc_hd__a31o_1
XFILLER_50_123 VPWR VGND VPWR VGND sky130_ef_sc_hd__decap_12
X_3955_ _3111_ _3144_ net126 VGND VGND VPWR VPWR _3145_ sky130_fd_sc_hd__o21ai_1
X_6743_ _2658_ VGND VGND VPWR VPWR _2659_ sky130_fd_sc_hd__inv_2
X_6674_ _2574_ _2581_ VGND VGND VPWR VPWR _2583_ sky130_fd_sc_hd__nand2_1
XTAP_TAPCELL_ROW_21_505 VGND VPWR sky130_fd_sc_hd__tapvpwrvgnd_1
XFILLER_50_189 VGND VGND VPWR VPWR sky130_fd_sc_hd__decap_6
XFILLER_109_409 VGND VGND VPWR VPWR sky130_fd_sc_hd__fill_2
XTAP_TAPCELL_ROW_98_1426 VGND VPWR sky130_fd_sc_hd__tapvpwrvgnd_1
X_3886_ net126 _3077_ _3078_ _3073_ VGND VGND VPWR VPWR _3079_ sky130_fd_sc_hd__a31o_1
X_5625_ _1378_ _1379_ _1437_ _1438_ VGND VGND VPWR VPWR _1439_ sky130_fd_sc_hd__and4_1
X_5556_ _1361_ _1362_ _1355_ VGND VGND VPWR VPWR _1363_ sky130_fd_sc_hd__a21o_1
X_4507_ _0269_ _0270_ _0237_ VGND VGND VPWR VPWR _0272_ sky130_fd_sc_hd__a21o_1
XFILLER_105_615 VGND VGND VPWR VPWR sky130_fd_sc_hd__fill_1
XFILLER_2_208 VGND VGND VPWR VPWR sky130_fd_sc_hd__decap_8
X_5487_ _1284_ _1286_ _1287_ VGND VGND VPWR VPWR _1289_ sky130_fd_sc_hd__and3_1
XFILLER_104_125 VPWR VGND VPWR VGND sky130_ef_sc_hd__decap_12
X_4438_ _0200_ _0201_ _0202_ VGND VGND VPWR VPWR _0204_ sky130_fd_sc_hd__nand3_1
XFILLER_116_57 VPWR VGND VPWR VGND sky130_ef_sc_hd__decap_12
X_4369_ _0121_ _0135_ _0136_ VGND VGND VPWR VPWR _0137_ sky130_fd_sc_hd__and3_1
XFILLER_86_521 VGND VGND VPWR VPWR sky130_fd_sc_hd__decap_8
XFILLER_112_191 VGND VGND VPWR VPWR sky130_fd_sc_hd__decap_4
XFILLER_86_554 VGND VGND VPWR VPWR sky130_fd_sc_hd__decap_8
XFILLER_58_234 VGND VGND VPWR VPWR sky130_fd_sc_hd__decap_8
X_6108_ _2150_ _1963_ VGND VGND VPWR VPWR _1966_ sky130_fd_sc_hd__or2_1
XFILLER_86_587 VGND VGND VPWR VPWR sky130_fd_sc_hd__fill_1
XTAP_TAPCELL_ROW_57_936 VGND VPWR sky130_fd_sc_hd__tapvpwrvgnd_1
X_6039_ _1886_ _1888_ _1889_ VGND VGND VPWR VPWR _1890_ sky130_fd_sc_hd__nand3_1
XTAP_TAPCELL_ROW_29_605 VGND VPWR sky130_fd_sc_hd__tapvpwrvgnd_1
XTAP_TAPCELL_ROW_107_1533 VGND VPWR sky130_fd_sc_hd__tapvpwrvgnd_1
XFILLER_92_27 VGND VGND VPWR VPWR sky130_fd_sc_hd__fill_1
XFILLER_54_473 VGND VGND VPWR VPWR sky130_fd_sc_hd__decap_3
XTAP_TAPCELL_ROW_1_263 VGND VPWR sky130_fd_sc_hd__tapvpwrvgnd_1
XFILLER_27_665 VGND VGND VPWR VPWR sky130_fd_sc_hd__decap_6
XFILLER_81_270 VGND VGND VPWR VPWR sky130_fd_sc_hd__fill_2
XFILLER_26_186 VGND VGND VPWR VPWR sky130_fd_sc_hd__decap_8
XTAP_TAPCELL_ROW_37_693 VGND VPWR sky130_fd_sc_hd__tapvpwrvgnd_1
XFILLER_25_87 VGND VGND VPWR VPWR sky130_fd_sc_hd__fill_1
XFILLER_42_657 VPWR VGND VPWR VGND sky130_ef_sc_hd__decap_12
XFILLER_10_587 VGND VGND VPWR VPWR sky130_fd_sc_hd__fill_1
XFILLER_6_569 VPWR VGND VPWR VGND sky130_ef_sc_hd__decap_12
XTAP_TAPCELL_ROW_71_1109 VGND VPWR sky130_fd_sc_hd__tapvpwrvgnd_1
XFILLER_111_629 VPWR VGND VPWR VGND sky130_ef_sc_hd__decap_12
XTAP_TAPCELL_ROW_9_363 VGND VPWR sky130_fd_sc_hd__tapvpwrvgnd_1
XFILLER_110_139 VGND VGND VPWR VPWR sky130_fd_sc_hd__fill_1
XFILLER_104_681 VGND VGND VPWR VPWR sky130_fd_sc_hd__decap_8
XFILLER_49_212 VPWR VGND VPWR VGND sky130_ef_sc_hd__decap_12
XFILLER_49_278 VGND VGND VPWR VPWR sky130_fd_sc_hd__fill_2
XFILLER_64_259 VGND VGND VPWR VPWR sky130_fd_sc_hd__fill_2
XFILLER_64_237 VGND VGND VPWR VPWR sky130_fd_sc_hd__fill_1
XFILLER_18_643 VGND VGND VPWR VPWR sky130_fd_sc_hd__fill_1
XFILLER_45_440 VGND VGND VPWR VPWR sky130_fd_sc_hd__decap_8
XFILLER_45_473 VGND VGND VPWR VPWR sky130_fd_sc_hd__decap_4
XTAP_TAPCELL_ROW_82_1238 VGND VPWR sky130_fd_sc_hd__tapvpwrvgnd_1
XFILLER_32_112 VGND VGND VPWR VPWR sky130_fd_sc_hd__decap_3
XFILLER_45_484 VGND VGND VPWR VPWR sky130_fd_sc_hd__decap_3
X_3740_ net133 _2920_ _2930_ _2931_ VGND VGND VPWR VPWR _2940_ sky130_fd_sc_hd__a22o_1
XANTENNA_19 net40 VGND VGND VPWR VPWR sky130_fd_sc_hd__diode_2
X_3671_ _0808_ net408 VGND VGND VPWR VPWR _2873_ sky130_fd_sc_hd__and2_1
X_5410_ _1202_ _1203_ _1100_ VGND VGND VPWR VPWR _1205_ sky130_fd_sc_hd__o21a_1
XFILLER_63_3 VGND VGND VPWR VPWR sky130_fd_sc_hd__fill_1
X_6390_ net281 net20 _2273_ VGND VGND VPWR VPWR _2274_ sky130_fd_sc_hd__nand3_1
Xoutput104 net104 VGND VGND VPWR VPWR return_port[5] sky130_fd_sc_hd__clkbuf_4
X_5341_ _1119_ _1126_ _1127_ VGND VGND VPWR VPWR _1129_ sky130_fd_sc_hd__nand3_2
XFILLER_114_445 VPWR VGND VPWR VGND sky130_ef_sc_hd__decap_12
XTAP_TAPCELL_ROW_93_1367 VGND VPWR sky130_fd_sc_hd__tapvpwrvgnd_1
X_5272_ _0946_ _0948_ _0947_ VGND VGND VPWR VPWR _1054_ sky130_fd_sc_hd__a21bo_1
XFILLER_114_489 VPWR VGND VPWR VGND sky130_ef_sc_hd__decap_12
XFILLER_101_106 VGND VGND VPWR VPWR sky130_fd_sc_hd__decap_6
XFILLER_87_329 VGND VGND VPWR VPWR sky130_fd_sc_hd__decap_6
X_4223_ net134 _3390_ _3400_ net128 VGND VGND VPWR VPWR _3401_ sky130_fd_sc_hd__o211a_1
XFILLER_68_565 VGND VGND VPWR VPWR sky130_fd_sc_hd__decap_8
X_4154_ _0874_ net257 _3322_ VGND VGND VPWR VPWR _3335_ sky130_fd_sc_hd__o21bai_1
X_4085_ _3265_ _3268_ VGND VGND VPWR VPWR _3269_ sky130_fd_sc_hd__and2b_1
XFILLER_55_237 VPWR VGND VPWR VGND sky130_ef_sc_hd__decap_12
XFILLER_102_15 VPWR VGND VPWR VGND sky130_ef_sc_hd__decap_12
XFILLER_83_568 VGND VGND VPWR VPWR sky130_fd_sc_hd__decap_8
XFILLER_63_281 VGND VGND VPWR VPWR sky130_fd_sc_hd__decap_8
XFILLER_24_613 VPWR VGND VPWR VGND sky130_ef_sc_hd__decap_12
XFILLER_51_421 VPWR VGND VPWR VGND sky130_ef_sc_hd__decap_12
XFILLER_24_657 VPWR VGND VPWR VGND sky130_ef_sc_hd__decap_12
XFILLER_51_465 VPWR VGND VPWR VGND sky130_ef_sc_hd__decap_12
X_4987_ _0732_ _0743_ VGND VGND VPWR VPWR _0745_ sky130_fd_sc_hd__xnor2_1
XTAP_TAPCELL_ROW_62_994 VGND VPWR sky130_fd_sc_hd__tapvpwrvgnd_1
X_6726_ _2601_ _2639_ VGND VGND VPWR VPWR _2640_ sky130_fd_sc_hd__nand2_1
XTAP_TAPCELL_ROW_34_663 VGND VPWR sky130_fd_sc_hd__tapvpwrvgnd_1
XTAP_TAPCELL_ROW_102_1474 VGND VPWR sky130_fd_sc_hd__tapvpwrvgnd_1
X_3938_ _3114_ _3128_ VGND VGND VPWR VPWR _3129_ sky130_fd_sc_hd__nand2_1
X_3869_ net232 _2881_ VGND VGND VPWR VPWR _3063_ sky130_fd_sc_hd__nand2_1
X_6657_ net329 _2563_ _2562_ VGND VGND VPWR VPWR _2565_ sky130_fd_sc_hd__a21bo_1
X_5608_ _1417_ _1418_ _1414_ VGND VGND VPWR VPWR _1421_ sky130_fd_sc_hd__a21o_1
X_6588_ _2318_ _2322_ _2487_ _2488_ VGND VGND VPWR VPWR _2490_ sky130_fd_sc_hd__a211oi_1
XFILLER_105_401 VGND VGND VPWR VPWR sky130_fd_sc_hd__fill_1
X_5539_ _1341_ _1343_ VGND VGND VPWR VPWR _1345_ sky130_fd_sc_hd__xor2_1
XFILLER_3_517 VPWR VGND VPWR VGND sky130_ef_sc_hd__decap_12
XFILLER_11_89 VGND VGND VPWR VPWR sky130_fd_sc_hd__fill_2
XPHY_EDGE_ROW_52_Left_169 VGND VGND VPWR VPWR sky130_fd_sc_hd__decap_3
XTAP_TAPCELL_ROW_6_322 VGND VPWR sky130_fd_sc_hd__tapvpwrvgnd_1
Xfanout320 net322 VGND VGND VPWR VPWR net320 sky130_fd_sc_hd__buf_4
Xfanout331 net333 VGND VGND VPWR VPWR net331 sky130_fd_sc_hd__buf_2
Xfanout342 net343 VGND VGND VPWR VPWR net342 sky130_fd_sc_hd__dlymetal6s2s_1
Xfanout353 net33 VGND VGND VPWR VPWR net353 sky130_fd_sc_hd__buf_2
Xfanout364 net366 VGND VGND VPWR VPWR net364 sky130_fd_sc_hd__clkbuf_2
XFILLER_59_543 VGND VGND VPWR VPWR sky130_fd_sc_hd__fill_1
XFILLER_59_532 VGND VGND VPWR VPWR sky130_fd_sc_hd__fill_1
Xfanout375 net376 VGND VGND VPWR VPWR net375 sky130_fd_sc_hd__clkbuf_4
Xfanout386 net387 VGND VGND VPWR VPWR net386 sky130_fd_sc_hd__buf_2
XFILLER_101_673 VPWR VGND VPWR VGND sky130_ef_sc_hd__decap_12
XFILLER_59_587 VGND VGND VPWR VPWR sky130_fd_sc_hd__decap_6
Xfanout397 net28 VGND VGND VPWR VPWR net397 sky130_fd_sc_hd__clkbuf_4
XFILLER_36_53 VPWR VGND VPWR VGND sky130_ef_sc_hd__decap_12
XTAP_TAPCELL_ROW_68_1071 VGND VPWR sky130_fd_sc_hd__tapvpwrvgnd_1
XPHY_EDGE_ROW_61_Left_178 VGND VGND VPWR VPWR sky130_fd_sc_hd__decap_3
XFILLER_14_156 VPWR VGND VPWR VGND sky130_ef_sc_hd__decap_12
XFILLER_52_74 VGND VGND VPWR VPWR sky130_fd_sc_hd__decap_8
XFILLER_52_85 VGND VGND VPWR VPWR sky130_fd_sc_hd__decap_8
Xinput17 a[24] VGND VGND VPWR VPWR net17 sky130_fd_sc_hd__clkbuf_1
Xinput28 a[5] VGND VGND VPWR VPWR net28 sky130_fd_sc_hd__clkbuf_4
Xinput39 b[15] VGND VGND VPWR VPWR net39 sky130_fd_sc_hd__buf_1
XPHY_EDGE_ROW_70_Left_187 VGND VGND VPWR VPWR sky130_fd_sc_hd__decap_3
XFILLER_108_272 VGND VGND VPWR VPWR sky130_fd_sc_hd__fill_1
XFILLER_77_384 VGND VGND VPWR VPWR sky130_fd_sc_hd__decap_3
XFILLER_65_502 VGND VGND VPWR VPWR sky130_fd_sc_hd__fill_2
XFILLER_37_237 VPWR VGND VPWR VGND sky130_ef_sc_hd__decap_12
X_4910_ _0666_ _0667_ _0663_ VGND VGND VPWR VPWR _0669_ sky130_fd_sc_hd__a21o_1
XFILLER_92_398 VGND VGND VPWR VPWR sky130_fd_sc_hd__decap_4
XFILLER_92_387 VGND VGND VPWR VPWR sky130_fd_sc_hd__fill_1
XFILLER_93_81 VPWR VGND VPWR VGND sky130_ef_sc_hd__decap_12
X_5890_ net451 net264 net256 net468 VGND VGND VPWR VPWR _1728_ sky130_fd_sc_hd__a22oi_1
XFILLER_18_484 VPWR VGND VPWR VGND sky130_ef_sc_hd__decap_12
X_4841_ _0597_ _0599_ _0521_ _0523_ VGND VGND VPWR VPWR _0601_ sky130_fd_sc_hd__o211ai_1
XFILLER_60_251 VGND VGND VPWR VPWR sky130_fd_sc_hd__fill_1
X_4772_ _0459_ _0462_ _0531_ _0532_ VGND VGND VPWR VPWR _0533_ sky130_fd_sc_hd__o211a_1
XTAP_TAPCELL_ROW_31_622 VGND VPWR sky130_fd_sc_hd__tapvpwrvgnd_1
X_3723_ _2896_ _2901_ _2902_ _2922_ VGND VGND VPWR VPWR _2923_ sky130_fd_sc_hd__a31o_1
X_6511_ net258 net218 net314 net305 VGND VGND VPWR VPWR _2406_ sky130_fd_sc_hd__and4_1
X_3654_ net131 _2845_ _2856_ VGND VGND VPWR VPWR _2857_ sky130_fd_sc_hd__a21oi_1
X_6442_ _2012_ _2170_ _2329_ _2169_ VGND VGND VPWR VPWR _2331_ sky130_fd_sc_hd__o211a_1
X_3585_ net250 net423 VGND VGND VPWR VPWR _2728_ sky130_fd_sc_hd__nor2_1
X_6373_ _2252_ _2253_ _2241_ VGND VGND VPWR VPWR _2255_ sky130_fd_sc_hd__o21a_1
XFILLER_114_253 VGND VGND VPWR VPWR sky130_fd_sc_hd__fill_1
X_5324_ _1108_ _1109_ VGND VGND VPWR VPWR _1110_ sky130_fd_sc_hd__and2_1
X_5255_ _1032_ _1033_ _0970_ VGND VGND VPWR VPWR _1035_ sky130_fd_sc_hd__a21oi_2
X_4206_ net21 net428 net19 net436 net348 net281 VGND VGND VPWR VPWR _3385_ sky130_fd_sc_hd__mux4_1
XFILLER_68_373 VGND VGND VPWR VPWR sky130_fd_sc_hd__fill_2
XFILLER_68_362 VGND VGND VPWR VPWR sky130_fd_sc_hd__fill_2
XFILLER_68_351 VGND VGND VPWR VPWR sky130_fd_sc_hd__decap_6
X_5186_ net409 net321 VGND VGND VPWR VPWR _0960_ sky130_fd_sc_hd__nand2_1
XFILLER_68_384 VGND VGND VPWR VPWR sky130_fd_sc_hd__fill_2
XTAP_TAPCELL_ROW_39_722 VGND VPWR sky130_fd_sc_hd__tapvpwrvgnd_1
X_4137_ net128 _3317_ _3318_ VGND VGND VPWR VPWR _3319_ sky130_fd_sc_hd__and3_1
XFILLER_113_69 VPWR VGND VPWR VGND sky130_ef_sc_hd__decap_12
XFILLER_83_365 VGND VGND VPWR VPWR sky130_fd_sc_hd__decap_4
XFILLER_71_505 VPWR VGND VPWR VGND sky130_ef_sc_hd__decap_12
X_4068_ _0852_ net271 VGND VGND VPWR VPWR _3253_ sky130_fd_sc_hd__or2_1
XTAP_TAPCELL_ROW_104_1503 VGND VPWR sky130_fd_sc_hd__tapvpwrvgnd_1
XFILLER_83_387 VGND VGND VPWR VPWR sky130_fd_sc_hd__decap_4
XFILLER_24_421 VGND VGND VPWR VPWR sky130_fd_sc_hd__fill_1
XFILLER_24_432 VGND VGND VPWR VPWR sky130_fd_sc_hd__decap_6
XFILLER_11_159 VGND VGND VPWR VPWR sky130_fd_sc_hd__decap_8
XFILLER_7_108 VGND VGND VPWR VPWR sky130_fd_sc_hd__decap_4
X_6709_ net438 net198 VGND VGND VPWR VPWR _2622_ sky130_fd_sc_hd__nand2_1
XFILLER_98_15 VPWR VGND VPWR VGND sky130_ef_sc_hd__decap_12
XTAP_TAPCELL_ROW_115_1632 VGND VPWR sky130_fd_sc_hd__tapvpwrvgnd_1
XFILLER_3_358 VGND VGND VPWR VPWR sky130_fd_sc_hd__decap_4
XFILLER_105_264 VPWR VGND VPWR VGND sky130_ef_sc_hd__decap_12
XFILLER_78_115 VPWR VGND VPWR VGND sky130_ef_sc_hd__decap_12
Xfanout183 net184 VGND VGND VPWR VPWR net183 sky130_fd_sc_hd__clkbuf_2
XFILLER_93_107 VGND VGND VPWR VPWR sky130_fd_sc_hd__decap_4
XFILLER_87_671 VGND VGND VPWR VPWR sky130_fd_sc_hd__fill_1
Xfanout172 net173 VGND VGND VPWR VPWR net172 sky130_fd_sc_hd__clkbuf_4
Xfanout150 _0045_ VGND VGND VPWR VPWR net150 sky130_fd_sc_hd__buf_2
Xfanout161 net162 VGND VGND VPWR VPWR net161 sky130_fd_sc_hd__clkbuf_4
Xfanout194 net196 VGND VGND VPWR VPWR net194 sky130_fd_sc_hd__clkbuf_4
XFILLER_101_481 VGND VGND VPWR VPWR sky130_fd_sc_hd__fill_1
XFILLER_74_321 VGND VGND VPWR VPWR sky130_fd_sc_hd__decap_8
XFILLER_19_248 VGND VGND VPWR VPWR sky130_fd_sc_hd__decap_4
XFILLER_19_259 VPWR VGND VPWR VGND sky130_ef_sc_hd__decap_12
XFILLER_63_40 VGND VGND VPWR VPWR sky130_fd_sc_hd__fill_1
XFILLER_27_281 VPWR VGND VPWR VGND sky130_ef_sc_hd__decap_12
XFILLER_11_671 VGND VGND VPWR VPWR sky130_fd_sc_hd__fill_1
XFILLER_116_529 VGND VGND VPWR VPWR sky130_fd_sc_hd__decap_3
XFILLER_7_653 VPWR VGND VPWR VGND sky130_ef_sc_hd__decap_12
XFILLER_6_174 VGND VGND VPWR VPWR sky130_fd_sc_hd__decap_4
XTAP_TAPCELL_ROW_90_1337 VGND VPWR sky130_fd_sc_hd__tapvpwrvgnd_1
XTAP_TAPCELL_ROW_90_1326 VGND VPWR sky130_fd_sc_hd__tapvpwrvgnd_1
X_5040_ net409 net402 net334 net328 VGND VGND VPWR VPWR _0801_ sky130_fd_sc_hd__nand4_1
XPHY_EDGE_ROW_108_Left_225 VGND VGND VPWR VPWR sky130_fd_sc_hd__decap_3
XFILLER_26_3 VPWR VGND VPWR VGND sky130_ef_sc_hd__decap_12
XFILLER_93_641 VPWR VGND VPWR VGND sky130_ef_sc_hd__decap_12
XFILLER_53_505 VGND VGND VPWR VPWR sky130_fd_sc_hd__decap_8
XFILLER_93_685 VGND VGND VPWR VPWR sky130_fd_sc_hd__decap_6
XFILLER_65_376 VPWR VGND VPWR VGND sky130_ef_sc_hd__decap_12
X_5942_ _1782_ _1783_ _1784_ VGND VGND VPWR VPWR _1785_ sky130_fd_sc_hd__and3_1
XFILLER_80_357 VGND VGND VPWR VPWR sky130_fd_sc_hd__decap_3
X_5873_ _1706_ _1708_ _1565_ _1567_ VGND VGND VPWR VPWR _1710_ sky130_fd_sc_hd__o211ai_2
X_4824_ net365 net216 _0582_ _0583_ VGND VGND VPWR VPWR _0584_ sky130_fd_sc_hd__a22o_1
XFILLER_61_582 VPWR VGND VPWR VGND sky130_ef_sc_hd__decap_12
XTAP_TAPCELL_ROW_44_780 VGND VPWR sky130_fd_sc_hd__tapvpwrvgnd_1
X_4755_ _0417_ _0514_ _0515_ VGND VGND VPWR VPWR _0516_ sky130_fd_sc_hd__nand3_2
X_3706_ net139 _2894_ VGND VGND VPWR VPWR _2907_ sky130_fd_sc_hd__nand2_1
X_4686_ _0435_ _0446_ _0447_ VGND VGND VPWR VPWR _0448_ sky130_fd_sc_hd__nand3_1
X_3637_ _1277_ _2827_ _2840_ VGND VGND VPWR VPWR _2841_ sky130_fd_sc_hd__o21ai_1
X_6425_ _2110_ _2157_ _2310_ _2311_ VGND VGND VPWR VPWR _2312_ sky130_fd_sc_hd__a211oi_1
X_3568_ net279 net159 VGND VGND VPWR VPWR _2542_ sky130_fd_sc_hd__nor2_1
X_6356_ _2235_ _2234_ VGND VGND VPWR VPWR _2236_ sky130_fd_sc_hd__and2b_1
XFILLER_115_573 VPWR VGND VPWR VGND sky130_ef_sc_hd__decap_12
X_5307_ _1089_ _1090_ _0903_ _0905_ VGND VGND VPWR VPWR _1093_ sky130_fd_sc_hd__o211a_1
XFILLER_68_29 VPWR VGND VPWR VGND sky130_ef_sc_hd__decap_12
XFILLER_68_18 VGND VGND VPWR VPWR sky130_fd_sc_hd__decap_8
XFILLER_102_234 VPWR VGND VPWR VGND sky130_ef_sc_hd__decap_12
X_3499_ net473 net456 net423 net416 net356 net289 VGND VGND VPWR VPWR _1790_ sky130_fd_sc_hd__mux4_1
X_6287_ _1993_ _1996_ _2159_ _2160_ VGND VGND VPWR VPWR _2162_ sky130_fd_sc_hd__a211oi_2
XTAP_TAPCELL_ROW_110_1573 VGND VPWR sky130_fd_sc_hd__tapvpwrvgnd_1
XFILLER_76_619 VPWR VGND VPWR VGND sky130_ef_sc_hd__decap_12
XFILLER_69_671 VGND VGND VPWR VPWR sky130_fd_sc_hd__fill_1
X_5238_ net313 net262 net207 net200 VGND VGND VPWR VPWR _1017_ sky130_fd_sc_hd__nand4_2
XFILLER_29_502 VGND VGND VPWR VPWR sky130_fd_sc_hd__fill_2
X_5169_ net372 net365 net187 net342 VGND VGND VPWR VPWR _0942_ sky130_fd_sc_hd__and4_1
XFILLER_29_524 VPWR VGND VPWR VGND sky130_ef_sc_hd__decap_12
XFILLER_56_365 VGND VGND VPWR VPWR sky130_fd_sc_hd__fill_2
XFILLER_17_55 VGND VGND VPWR VPWR sky130_fd_sc_hd__fill_1
XFILLER_71_346 VPWR VGND VPWR VGND sky130_ef_sc_hd__decap_12
XFILLER_71_335 VGND VGND VPWR VPWR sky130_fd_sc_hd__fill_1
XTAP_TAPCELL_ROW_65_1030 VGND VPWR sky130_fd_sc_hd__tapvpwrvgnd_1
XTAP_TAPCELL_ROW_14_419 VGND VPWR sky130_fd_sc_hd__tapvpwrvgnd_1
XFILLER_24_251 VGND VGND VPWR VPWR sky130_fd_sc_hd__fill_1
XFILLER_24_295 VGND VGND VPWR VPWR sky130_fd_sc_hd__decap_4
XFILLER_12_457 VPWR VGND VPWR VGND sky130_ef_sc_hd__decap_12
XFILLER_4_601 VPWR VGND VPWR VGND sky130_ef_sc_hd__decap_12
XFILLER_4_645 VPWR VGND VPWR VGND sky130_ef_sc_hd__decap_12
XFILLER_4_689 VGND VGND VPWR VPWR sky130_fd_sc_hd__decap_3
XFILLER_94_416 VGND VGND VPWR VPWR sky130_fd_sc_hd__decap_4
XFILLER_66_129 VGND VGND VPWR VPWR sky130_fd_sc_hd__fill_2
XFILLER_75_641 VPWR VGND VPWR VGND sky130_ef_sc_hd__decap_12
XFILLER_47_354 VPWR VGND VPWR VGND sky130_ef_sc_hd__decap_12
XFILLER_75_685 VGND VGND VPWR VPWR sky130_fd_sc_hd__decap_6
XFILLER_35_538 VGND VGND VPWR VPWR sky130_fd_sc_hd__fill_1
XFILLER_70_390 VGND VGND VPWR VPWR sky130_fd_sc_hd__decap_8
XFILLER_30_232 VPWR VGND VPWR VGND sky130_ef_sc_hd__decap_12
X_4540_ _0300_ _0301_ _0302_ VGND VGND VPWR VPWR _0304_ sky130_fd_sc_hd__nand3_1
X_4471_ net472 net455 net196 net191 VGND VGND VPWR VPWR _0236_ sky130_fd_sc_hd__and4_1
Xmax_cap114 _0527_ VGND VGND VPWR VPWR net114 sky130_fd_sc_hd__clkbuf_1
X_6210_ net171 net336 VGND VGND VPWR VPWR _2077_ sky130_fd_sc_hd__nand2_1
X_3422_ net316 VGND VGND VPWR VPWR _0950_ sky130_fd_sc_hd__inv_2
X_6141_ net109 _2000_ _1799_ _1846_ VGND VGND VPWR VPWR _2002_ sky130_fd_sc_hd__o211ai_2
XFILLER_112_587 VGND VGND VPWR VPWR sky130_fd_sc_hd__fill_1
X_6072_ net309 net319 _1923_ _1924_ VGND VGND VPWR VPWR _1926_ sky130_fd_sc_hd__a22o_1
X_5023_ _0779_ _0780_ _0781_ VGND VGND VPWR VPWR _0783_ sky130_fd_sc_hd__o21bai_1
XFILLER_38_321 VPWR VGND VPWR VGND sky130_ef_sc_hd__decap_12
XFILLER_93_482 VGND VGND VPWR VPWR sky130_fd_sc_hd__fill_1
XFILLER_38_365 VPWR VGND VPWR VGND sky130_ef_sc_hd__decap_12
XFILLER_110_15 VPWR VGND VPWR VGND sky130_ef_sc_hd__decap_12
XFILLER_0_91 VGND VGND VPWR VPWR sky130_fd_sc_hd__decap_8
X_5925_ net219 net337 _1764_ _1765_ VGND VGND VPWR VPWR _1766_ sky130_fd_sc_hd__nand4_1
XFILLER_34_560 VGND VGND VPWR VPWR sky130_fd_sc_hd__fill_1
XFILLER_21_210 VPWR VGND VPWR VGND sky130_ef_sc_hd__decap_12
X_5856_ _1551_ _1554_ _1688_ _1690_ VGND VGND VPWR VPWR _1691_ sky130_fd_sc_hd__a211o_2
X_4807_ _0565_ _0566_ _0564_ VGND VGND VPWR VPWR _0567_ sky130_fd_sc_hd__a21o_1
XPHY_EDGE_ROW_3_Right_3 VGND VGND VPWR VPWR sky130_fd_sc_hd__decap_3
XFILLER_21_287 VGND VGND VPWR VPWR sky130_fd_sc_hd__decap_8
X_5787_ net175 net186 net341 net219 VGND VGND VPWR VPWR _1616_ sky130_fd_sc_hd__a22o_1
X_4738_ _0497_ _0498_ VGND VGND VPWR VPWR _0499_ sky130_fd_sc_hd__nor2_1
XFILLER_107_337 VGND VGND VPWR VPWR sky130_fd_sc_hd__decap_6
X_4669_ _0419_ _0430_ VGND VGND VPWR VPWR _0431_ sky130_fd_sc_hd__nand2_1
X_6408_ _2283_ _2291_ VGND VGND VPWR VPWR _2294_ sky130_fd_sc_hd__xor2_1
XFILLER_1_615 VGND VGND VPWR VPWR sky130_fd_sc_hd__fill_1
XFILLER_88_243 VGND VGND VPWR VPWR sky130_fd_sc_hd__decap_8
X_6339_ _2054_ _2056_ _2216_ _2217_ VGND VGND VPWR VPWR _2218_ sky130_fd_sc_hd__a211oi_2
XFILLER_95_27 VPWR VGND VPWR VGND sky130_ef_sc_hd__decap_12
XFILLER_88_265 VPWR VGND VPWR VGND sky130_ef_sc_hd__decap_12
XFILLER_69_490 VGND VGND VPWR VPWR sky130_fd_sc_hd__decap_4
XFILLER_28_65 VPWR VGND VPWR VGND sky130_ef_sc_hd__decap_12
XFILLER_91_419 VGND VGND VPWR VPWR sky130_fd_sc_hd__fill_2
XFILLER_57_685 VGND VGND VPWR VPWR sky130_fd_sc_hd__decap_6
XFILLER_17_505 VGND VGND VPWR VPWR sky130_fd_sc_hd__fill_2
XFILLER_44_357 VGND VGND VPWR VPWR sky130_fd_sc_hd__decap_6
XTAP_TAPCELL_ROW_27_577 VGND VPWR sky130_fd_sc_hd__tapvpwrvgnd_1
XFILLER_44_53 VGND VGND VPWR VPWR sky130_fd_sc_hd__decap_8
XFILLER_12_221 VGND VGND VPWR VPWR sky130_fd_sc_hd__fill_1
XFILLER_40_574 VPWR VGND VPWR VGND sky130_ef_sc_hd__decap_12
XFILLER_60_74 VGND VGND VPWR VPWR sky130_fd_sc_hd__fill_2
XFILLER_60_85 VGND VGND VPWR VPWR sky130_fd_sc_hd__decap_4
XFILLER_4_475 VGND VGND VPWR VPWR sky130_fd_sc_hd__fill_1
XFILLER_67_416 VPWR VGND VPWR VGND sky130_ef_sc_hd__decap_12
XFILLER_94_202 VGND VGND VPWR VPWR sky130_fd_sc_hd__decap_8
XFILLER_67_449 VGND VGND VPWR VPWR sky130_fd_sc_hd__fill_2
XFILLER_94_257 VPWR VGND VPWR VGND sky130_ef_sc_hd__decap_12
XFILLER_47_140 VGND VGND VPWR VPWR sky130_fd_sc_hd__decap_3
XFILLER_75_471 VGND VGND VPWR VPWR sky130_fd_sc_hd__decap_4
XFILLER_47_162 VGND VGND VPWR VPWR sky130_fd_sc_hd__decap_6
XFILLER_35_335 VGND VGND VPWR VPWR sky130_fd_sc_hd__fill_1
XFILLER_90_474 VGND VGND VPWR VPWR sky130_fd_sc_hd__fill_2
XTAP_TAPCELL_ROW_85_1269 VGND VPWR sky130_fd_sc_hd__tapvpwrvgnd_1
X_3971_ net465 net298 VGND VGND VPWR VPWR _3160_ sky130_fd_sc_hd__or2_1
XFILLER_50_305 VGND VGND VPWR VPWR sky130_fd_sc_hd__decap_3
XFILLER_16_582 VGND VGND VPWR VPWR sky130_fd_sc_hd__decap_6
X_5710_ _1530_ _1531_ VGND VGND VPWR VPWR _1532_ sky130_fd_sc_hd__xor2_2
X_6690_ _2420_ _2424_ VGND VGND VPWR VPWR _2601_ sky130_fd_sc_hd__or2_1
XFILLER_43_390 VGND VGND VPWR VPWR sky130_fd_sc_hd__fill_2
X_5641_ _1213_ _1456_ VGND VGND VPWR VPWR _1457_ sky130_fd_sc_hd__or2_1
XFILLER_31_596 VPWR VGND VPWR VGND sky130_ef_sc_hd__decap_12
X_5572_ net269 _1260_ _1380_ VGND VGND VPWR VPWR _1381_ sky130_fd_sc_hd__a21bo_1
X_4523_ _0284_ _0286_ _0287_ VGND VGND VPWR VPWR _0288_ sky130_fd_sc_hd__o21ai_1
X_4454_ net472 net196 _0217_ _0218_ VGND VGND VPWR VPWR _0220_ sky130_fd_sc_hd__nand4_1
XTAP_TAPCELL_ROW_96_1398 VGND VPWR sky130_fd_sc_hd__tapvpwrvgnd_1
X_4385_ net422 net214 VGND VGND VPWR VPWR _0152_ sky130_fd_sc_hd__nand2_1
X_3405_ net351 VGND VGND VPWR VPWR _0765_ sky130_fd_sc_hd__inv_2
XFILLER_105_15 VPWR VGND VPWR VGND sky130_ef_sc_hd__decap_12
XFILLER_58_405 VGND VGND VPWR VPWR sky130_fd_sc_hd__fill_1
X_6124_ _1979_ _1980_ _1968_ VGND VGND VPWR VPWR _1983_ sky130_fd_sc_hd__a21oi_1
X_6055_ _1905_ _1906_ VGND VGND VPWR VPWR _1907_ sky130_fd_sc_hd__xnor2_1
XFILLER_100_557 VPWR VGND VPWR VGND sky130_ef_sc_hd__decap_12
X_5006_ _0672_ _0674_ _0762_ _0763_ VGND VGND VPWR VPWR _0764_ sky130_fd_sc_hd__o211ai_2
XFILLER_65_19 VGND VGND VPWR VPWR sky130_fd_sc_hd__decap_3
XFILLER_39_641 VPWR VGND VPWR VGND sky130_ef_sc_hd__decap_12
XFILLER_54_622 VPWR VGND VPWR VGND sky130_ef_sc_hd__decap_12
XFILLER_39_685 VGND VGND VPWR VPWR sky130_fd_sc_hd__decap_6
XFILLER_53_110 VGND VGND VPWR VPWR sky130_fd_sc_hd__fill_2
XFILLER_41_305 VPWR VGND VPWR VGND sky130_ef_sc_hd__decap_12
XFILLER_53_154 VGND VGND VPWR VPWR sky130_fd_sc_hd__decap_3
XFILLER_81_485 VPWR VGND VPWR VGND sky130_ef_sc_hd__decap_12
XTAP_TAPCELL_ROW_62_1000 VGND VPWR sky130_fd_sc_hd__tapvpwrvgnd_1
XTAP_TAPCELL_ROW_24_536 VGND VPWR sky130_fd_sc_hd__tapvpwrvgnd_1
X_6888_ net181 _alu_i0.Datapath_i.fu_alu_33673_33851.out1\[14\] VGND VGND VPWR VPWR
+ _alu_i0.Datapath_i.reg_0.reg_out1\[14\] sky130_fd_sc_hd__dfxtp_1
XTAP_TAPCELL_ROW_52_878 VGND VPWR sky130_fd_sc_hd__tapvpwrvgnd_1
X_5908_ _1745_ _1747_ VGND VGND VPWR VPWR _1748_ sky130_fd_sc_hd__and2b_1
XFILLER_22_563 VGND VGND VPWR VPWR sky130_fd_sc_hd__fill_2
X_5839_ _2095_ _1672_ VGND VGND VPWR VPWR _1673_ sky130_fd_sc_hd__or2_1
XFILLER_108_613 VPWR VGND VPWR VGND sky130_ef_sc_hd__decap_12
XFILLER_108_657 VPWR VGND VPWR VGND sky130_ef_sc_hd__decap_12
XFILLER_30_77 VGND VGND VPWR VPWR sky130_fd_sc_hd__decap_6
XFILLER_89_585 VPWR VGND VPWR VGND sky130_ef_sc_hd__decap_12
XFILLER_76_213 VGND VGND VPWR VPWR sky130_fd_sc_hd__fill_1
XFILLER_49_449 VGND VGND VPWR VPWR sky130_fd_sc_hd__decap_4
XFILLER_76_268 VGND VGND VPWR VPWR sky130_fd_sc_hd__fill_1
XFILLER_64_408 VGND VGND VPWR VPWR sky130_fd_sc_hd__fill_1
XTAP_TAPCELL_ROW_4_294 VGND VPWR sky130_fd_sc_hd__tapvpwrvgnd_1
XFILLER_91_249 VPWR VGND VPWR VGND sky130_ef_sc_hd__decap_12
XFILLER_72_452 VGND VGND VPWR VPWR sky130_fd_sc_hd__fill_2
XFILLER_55_85 VGND VGND VPWR VPWR sky130_fd_sc_hd__decap_8
XFILLER_55_63 VGND VGND VPWR VPWR sky130_fd_sc_hd__fill_1
XFILLER_60_669 VPWR VGND VPWR VGND sky130_ef_sc_hd__decap_12
XFILLER_13_552 VGND VGND VPWR VPWR sky130_fd_sc_hd__decap_8
XFILLER_25_390 VGND VGND VPWR VPWR sky130_fd_sc_hd__fill_2
XFILLER_9_512 VGND VGND VPWR VPWR sky130_fd_sc_hd__decap_8
XFILLER_13_585 VPWR VGND VPWR VGND sky130_ef_sc_hd__decap_12
XFILLER_99_305 VPWR VGND VPWR VGND sky130_ef_sc_hd__decap_12
XFILLER_113_137 VGND VGND VPWR VPWR sky130_fd_sc_hd__fill_1
XFILLER_99_349 VPWR VGND VPWR VGND sky130_ef_sc_hd__decap_12
X_4170_ net428 net253 VGND VGND VPWR VPWR _3350_ sky130_fd_sc_hd__nand2_1
XFILLER_67_279 VGND VGND VPWR VPWR sky130_fd_sc_hd__fill_1
XFILLER_35_110 VGND VGND VPWR VPWR sky130_fd_sc_hd__fill_2
XFILLER_36_633 VGND VGND VPWR VPWR sky130_fd_sc_hd__decap_8
XFILLER_48_493 VGND VGND VPWR VPWR sky130_fd_sc_hd__fill_1
X_6811_ net405 net254 _2497_ _2496_ VGND VGND VPWR VPWR _2733_ sky130_fd_sc_hd__a31o_1
XFILLER_23_305 VGND VGND VPWR VPWR sky130_fd_sc_hd__decap_6
XFILLER_51_614 VGND VGND VPWR VPWR sky130_fd_sc_hd__fill_2
XFILLER_90_293 VPWR VGND VPWR VGND sky130_ef_sc_hd__decap_12
X_6742_ _2655_ _2656_ _2657_ VGND VGND VPWR VPWR _2658_ sky130_fd_sc_hd__nor3_1
XFILLER_50_135 VGND VGND VPWR VPWR sky130_fd_sc_hd__decap_4
X_3954_ _3141_ _3142_ VGND VGND VPWR VPWR _3144_ sky130_fd_sc_hd__nand2_2
X_3885_ _3075_ _3076_ VGND VGND VPWR VPWR _3078_ sky130_fd_sc_hd__or2_1
X_6673_ _2574_ _2581_ VGND VGND VPWR VPWR _2582_ sky130_fd_sc_hd__nor2_1
XTAP_TAPCELL_ROW_21_506 VGND VPWR sky130_fd_sc_hd__tapvpwrvgnd_1
XTAP_TAPCELL_ROW_98_1427 VGND VPWR sky130_fd_sc_hd__tapvpwrvgnd_1
X_5624_ _1434_ _1435_ _1313_ VGND VGND VPWR VPWR _1438_ sky130_fd_sc_hd__a21o_1
X_5555_ _1359_ _1360_ _1356_ VGND VGND VPWR VPWR _1362_ sky130_fd_sc_hd__a21o_1
X_4506_ _0237_ _0269_ _0270_ VGND VGND VPWR VPWR _0271_ sky130_fd_sc_hd__nand3_2
X_5486_ _1160_ _1162_ _1161_ VGND VGND VPWR VPWR _1287_ sky130_fd_sc_hd__a21bo_1
XFILLER_104_137 VGND VGND VPWR VPWR sky130_fd_sc_hd__decap_3
X_4437_ _0200_ _0201_ _0202_ VGND VGND VPWR VPWR _0203_ sky130_fd_sc_hd__a21o_1
XFILLER_116_69 VPWR VGND VPWR VGND sky130_ef_sc_hd__decap_12
XFILLER_113_671 VGND VGND VPWR VPWR sky130_fd_sc_hd__fill_1
X_4368_ net355 net391 _0133_ _0134_ VGND VGND VPWR VPWR _0136_ sky130_fd_sc_hd__nand4_1
XFILLER_86_533 VPWR VGND VPWR VGND sky130_ef_sc_hd__decap_12
XFILLER_76_29 VGND VGND VPWR VPWR sky130_fd_sc_hd__decap_8
XFILLER_58_202 VGND VGND VPWR VPWR sky130_fd_sc_hd__decap_8
X_6107_ _2150_ _1963_ VGND VGND VPWR VPWR _1965_ sky130_fd_sc_hd__nand2_1
XFILLER_100_321 VGND VGND VPWR VPWR sky130_fd_sc_hd__decap_8
X_4299_ _0054_ _0067_ VGND VGND VPWR VPWR _0070_ sky130_fd_sc_hd__nand2_1
XFILLER_100_354 VGND VGND VPWR VPWR sky130_fd_sc_hd__fill_1
XTAP_TAPCELL_ROW_57_937 VGND VPWR sky130_fd_sc_hd__tapvpwrvgnd_1
X_6038_ net395 net275 _1737_ _1736_ VGND VGND VPWR VPWR _1889_ sky130_fd_sc_hd__a31o_1
XTAP_TAPCELL_ROW_107_1534 VGND VPWR sky130_fd_sc_hd__tapvpwrvgnd_1
XTAP_TAPCELL_ROW_1_264 VGND VPWR sky130_fd_sc_hd__tapvpwrvgnd_1
XFILLER_54_496 VPWR VGND VPWR VGND sky130_ef_sc_hd__decap_12
XTAP_TAPCELL_ROW_37_694 VGND VPWR sky130_fd_sc_hd__tapvpwrvgnd_1
XFILLER_41_113 VPWR VGND VPWR VGND sky130_ef_sc_hd__decap_12
XFILLER_25_55 VGND VGND VPWR VPWR sky130_fd_sc_hd__fill_1
XFILLER_41_157 VGND VGND VPWR VPWR sky130_fd_sc_hd__decap_6
XFILLER_42_669 VPWR VGND VPWR VGND sky130_ef_sc_hd__decap_12
XFILLER_10_533 VPWR VGND VPWR VGND sky130_ef_sc_hd__decap_12
XFILLER_41_43 VGND VGND VPWR VPWR sky130_fd_sc_hd__decap_6
XTAP_TAPCELL_ROW_9_364 VGND VPWR sky130_fd_sc_hd__tapvpwrvgnd_1
XFILLER_110_107 VPWR VGND VPWR VGND sky130_ef_sc_hd__decap_12
XFILLER_77_533 VGND VGND VPWR VPWR sky130_fd_sc_hd__decap_3
XFILLER_77_500 VGND VGND VPWR VPWR sky130_fd_sc_hd__fill_1
XFILLER_2_15 VPWR VGND VPWR VGND sky130_ef_sc_hd__decap_12
XFILLER_103_181 VGND VGND VPWR VPWR sky130_fd_sc_hd__decap_6
XFILLER_89_393 VGND VGND VPWR VPWR sky130_fd_sc_hd__fill_1
XFILLER_1_297 VGND VGND VPWR VPWR sky130_fd_sc_hd__fill_2
XFILLER_64_205 VGND VGND VPWR VPWR sky130_fd_sc_hd__decap_8
XFILLER_37_419 VGND VGND VPWR VPWR sky130_fd_sc_hd__fill_1
XFILLER_60_411 VGND VGND VPWR VPWR sky130_fd_sc_hd__decap_6
XFILLER_17_187 VGND VGND VPWR VPWR sky130_fd_sc_hd__fill_1
XTAP_TAPCELL_ROW_82_1239 VGND VPWR sky130_fd_sc_hd__tapvpwrvgnd_1
XFILLER_17_198 VPWR VGND VPWR VGND sky130_ef_sc_hd__decap_12
XFILLER_82_94 VGND VGND VPWR VPWR sky130_fd_sc_hd__decap_8
XFILLER_60_477 VGND VGND VPWR VPWR sky130_fd_sc_hd__decap_6
XFILLER_41_691 VGND VGND VPWR VPWR sky130_fd_sc_hd__fill_1
X_3670_ _2870_ _2871_ VGND VGND VPWR VPWR _2872_ sky130_fd_sc_hd__nand2_1
XFILLER_9_375 VPWR VGND VPWR VGND sky130_ef_sc_hd__decap_12
Xoutput105 net105 VGND VGND VPWR VPWR return_port[6] sky130_fd_sc_hd__clkbuf_4
XFILLER_114_402 VPWR VGND VPWR VGND sky130_ef_sc_hd__decap_12
X_5340_ _1126_ _1127_ _1119_ VGND VGND VPWR VPWR _1128_ sky130_fd_sc_hd__a21o_1
XTAP_TAPCELL_ROW_93_1368 VGND VPWR sky130_fd_sc_hd__tapvpwrvgnd_1
X_5271_ _1049_ _1050_ _1051_ VGND VGND VPWR VPWR _1053_ sky130_fd_sc_hd__nand3_1
XFILLER_114_457 VPWR VGND VPWR VGND sky130_ef_sc_hd__decap_12
X_4222_ net142 _3392_ _3396_ _3399_ net134 VGND VGND VPWR VPWR _3400_ sky130_fd_sc_hd__o221ai_1
XFILLER_68_533 VGND VGND VPWR VPWR sky130_fd_sc_hd__decap_6
X_4153_ _3331_ _3332_ VGND VGND VPWR VPWR _3334_ sky130_fd_sc_hd__nand2_1
XFILLER_95_385 VGND VGND VPWR VPWR sky130_fd_sc_hd__decap_6
X_4084_ net440 net267 VGND VGND VPWR VPWR _3268_ sky130_fd_sc_hd__or2_1
XFILLER_55_249 VPWR VGND VPWR VGND sky130_ef_sc_hd__decap_12
XFILLER_102_27 VGND VGND VPWR VPWR sky130_fd_sc_hd__fill_1
XFILLER_70_208 VGND VGND VPWR VPWR sky130_fd_sc_hd__fill_2
XFILLER_63_260 VPWR VGND VPWR VGND sky130_ef_sc_hd__decap_12
XFILLER_23_113 VPWR VGND VPWR VGND sky130_ef_sc_hd__decap_12
XFILLER_24_625 VPWR VGND VPWR VGND sky130_ef_sc_hd__decap_12
XFILLER_36_485 VGND VGND VPWR VPWR sky130_fd_sc_hd__fill_2
X_4986_ _0732_ _0743_ VGND VGND VPWR VPWR _0744_ sky130_fd_sc_hd__nand2b_1
XFILLER_24_669 VPWR VGND VPWR VGND sky130_ef_sc_hd__decap_12
XFILLER_51_433 VGND VGND VPWR VPWR sky130_fd_sc_hd__fill_1
XFILLER_51_444 VGND VGND VPWR VPWR sky130_fd_sc_hd__decap_4
XTAP_TAPCELL_ROW_62_995 VGND VPWR sky130_fd_sc_hd__tapvpwrvgnd_1
X_3937_ _3081_ _3127_ _3126_ VGND VGND VPWR VPWR _3128_ sky130_fd_sc_hd__a21oi_1
X_6725_ _2617_ _2638_ VGND VGND VPWR VPWR _2639_ sky130_fd_sc_hd__xnor2_2
XTAP_TAPCELL_ROW_34_664 VGND VPWR sky130_fd_sc_hd__tapvpwrvgnd_1
XFILLER_51_477 VGND VGND VPWR VPWR sky130_fd_sc_hd__decap_3
XTAP_TAPCELL_ROW_102_1475 VGND VPWR sky130_fd_sc_hd__tapvpwrvgnd_1
X_3868_ net135 _3050_ _3061_ net129 VGND VGND VPWR VPWR _3062_ sky130_fd_sc_hd__o211a_1
X_6656_ net166 net464 net323 VGND VGND VPWR VPWR _2563_ sky130_fd_sc_hd__and3_1
X_3799_ net432 net364 net371 net378 net349 net280 VGND VGND VPWR VPWR _2996_ sky130_fd_sc_hd__mux4_1
X_5607_ _1414_ _1417_ _1418_ VGND VGND VPWR VPWR _1420_ sky130_fd_sc_hd__nand3_1
X_6587_ _2487_ _2488_ _2318_ _2322_ VGND VGND VPWR VPWR _2489_ sky130_fd_sc_hd__o211a_1
X_5538_ _1341_ _1343_ VGND VGND VPWR VPWR _1344_ sky130_fd_sc_hd__and2_1
XFILLER_11_57 VGND VGND VPWR VPWR sky130_fd_sc_hd__decap_8
XFILLER_3_529 VPWR VGND VPWR VGND sky130_ef_sc_hd__decap_12
XFILLER_105_446 VGND VGND VPWR VPWR sky130_fd_sc_hd__fill_2
X_5469_ _1262_ _1268_ VGND VGND VPWR VPWR _1269_ sky130_fd_sc_hd__and2_1
XFILLER_99_691 VGND VGND VPWR VPWR sky130_fd_sc_hd__fill_1
Xfanout332 net333 VGND VGND VPWR VPWR net332 sky130_fd_sc_hd__dlymetal6s2s_1
Xfanout321 net322 VGND VGND VPWR VPWR net321 sky130_fd_sc_hd__buf_4
XTAP_TAPCELL_ROW_6_323 VGND VPWR sky130_fd_sc_hd__tapvpwrvgnd_1
Xfanout310 net4 VGND VGND VPWR VPWR net310 sky130_fd_sc_hd__buf_2
XFILLER_101_641 VPWR VGND VPWR VGND sky130_ef_sc_hd__decap_12
XFILLER_98_190 VGND VGND VPWR VPWR sky130_fd_sc_hd__decap_6
XFILLER_86_341 VPWR VGND VPWR VGND sky130_ef_sc_hd__decap_12
Xfanout354 net355 VGND VGND VPWR VPWR net354 sky130_fd_sc_hd__clkbuf_4
Xfanout343 net34 VGND VGND VPWR VPWR net343 sky130_fd_sc_hd__buf_2
Xfanout365 net366 VGND VGND VPWR VPWR net365 sky130_fd_sc_hd__clkbuf_4
XFILLER_101_685 VGND VGND VPWR VPWR sky130_fd_sc_hd__decap_6
Xfanout387 net3 VGND VGND VPWR VPWR net387 sky130_fd_sc_hd__buf_4
Xfanout398 net399 VGND VGND VPWR VPWR net398 sky130_fd_sc_hd__buf_2
Xfanout376 net381 VGND VGND VPWR VPWR net376 sky130_fd_sc_hd__clkbuf_4
XFILLER_27_430 VGND VGND VPWR VPWR sky130_fd_sc_hd__decap_8
XTAP_TAPCELL_ROW_68_1072 VGND VPWR sky130_fd_sc_hd__tapvpwrvgnd_1
XFILLER_36_65 VPWR VGND VPWR VGND sky130_ef_sc_hd__decap_12
XFILLER_14_168 VPWR VGND VPWR VGND sky130_ef_sc_hd__decap_12
XFILLER_23_691 VGND VGND VPWR VPWR sky130_fd_sc_hd__fill_1
Xinput18 a[25] VGND VGND VPWR VPWR net18 sky130_fd_sc_hd__buf_1
XFILLER_10_363 VGND VGND VPWR VPWR sky130_fd_sc_hd__fill_1
Xinput29 a[6] VGND VGND VPWR VPWR net29 sky130_fd_sc_hd__clkbuf_4
XFILLER_6_356 VGND VGND VPWR VPWR sky130_fd_sc_hd__decap_8
XFILLER_108_284 VGND VGND VPWR VPWR sky130_fd_sc_hd__fill_2
XFILLER_97_617 VPWR VGND VPWR VGND sky130_ef_sc_hd__decap_12
XFILLER_111_405 VPWR VGND VPWR VGND sky130_ef_sc_hd__decap_12
XFILLER_96_105 VGND VGND VPWR VPWR sky130_fd_sc_hd__fill_2
XFILLER_77_352 VPWR VGND VPWR VGND sky130_ef_sc_hd__decap_12
XFILLER_77_83 VPWR VGND VPWR VGND sky130_ef_sc_hd__decap_12
XFILLER_92_344 VGND VGND VPWR VPWR sky130_fd_sc_hd__fill_1
XFILLER_37_249 VPWR VGND VPWR VGND sky130_ef_sc_hd__decap_12
XFILLER_93_93 VGND VGND VPWR VPWR sky130_fd_sc_hd__decap_6
XFILLER_73_580 VGND VGND VPWR VPWR sky130_fd_sc_hd__decap_4
X_4840_ _0521_ _0523_ _0597_ _0599_ VGND VGND VPWR VPWR _0600_ sky130_fd_sc_hd__a211o_1
XFILLER_60_274 VPWR VGND VPWR VGND sky130_ef_sc_hd__decap_12
XFILLER_21_617 VPWR VGND VPWR VGND sky130_ef_sc_hd__decap_12
X_4771_ _0455_ _0529_ _0530_ VGND VGND VPWR VPWR _0532_ sky130_fd_sc_hd__nand3_2
X_6510_ net218 net314 net305 net258 VGND VGND VPWR VPWR _2405_ sky130_fd_sc_hd__a22oi_1
XTAP_TAPCELL_ROW_31_623 VGND VPWR sky130_fd_sc_hd__tapvpwrvgnd_1
X_3722_ net209 net391 VGND VGND VPWR VPWR _2922_ sky130_fd_sc_hd__and2b_1
XFILLER_20_149 VGND VGND VPWR VPWR sky130_fd_sc_hd__fill_1
X_3653_ net134 _2843_ _2855_ net130 VGND VGND VPWR VPWR _2856_ sky130_fd_sc_hd__o211a_1
X_6441_ _2014_ _2169_ _2329_ VGND VGND VPWR VPWR _2330_ sky130_fd_sc_hd__and3_1
XTAP_TAPCELL_ROW_11_380 VGND VPWR sky130_fd_sc_hd__tapvpwrvgnd_1
X_6372_ _2241_ _2252_ _2253_ VGND VGND VPWR VPWR _2254_ sky130_fd_sc_hd__nor3_2
XFILLER_114_210 VPWR VGND VPWR VGND sky130_ef_sc_hd__decap_12
X_3584_ net249 net422 VGND VGND VPWR VPWR _2717_ sky130_fd_sc_hd__and2_2
X_5323_ _1000_ _1003_ VGND VGND VPWR VPWR _1109_ sky130_fd_sc_hd__nand2_1
XFILLER_114_232 VGND VGND VPWR VPWR sky130_fd_sc_hd__decap_3
XFILLER_114_265 VGND VGND VPWR VPWR sky130_fd_sc_hd__fill_1
X_5254_ _0970_ _1032_ _1033_ VGND VGND VPWR VPWR _1034_ sky130_fd_sc_hd__and3_2
X_5185_ _0957_ _0958_ VGND VGND VPWR VPWR _0959_ sky130_fd_sc_hd__nor2_1
X_4205_ net131 _3371_ _3383_ VGND VGND VPWR VPWR _3384_ sky130_fd_sc_hd__a21oi_1
X_4136_ net138 _3312_ _3313_ net142 VGND VGND VPWR VPWR _3318_ sky130_fd_sc_hd__o2bb2a_1
XFILLER_113_15 VPWR VGND VPWR VGND sky130_ef_sc_hd__decap_12
XTAP_TAPCELL_ROW_39_723 VGND VPWR sky130_fd_sc_hd__tapvpwrvgnd_1
X_4067_ net142 _3245_ _3251_ net135 VGND VGND VPWR VPWR _3252_ sky130_fd_sc_hd__o211a_1
XTAP_TAPCELL_ROW_104_1504 VGND VPWR sky130_fd_sc_hd__tapvpwrvgnd_1
XFILLER_71_517 VGND VGND VPWR VPWR sky130_fd_sc_hd__fill_1
XTAP_TAPCELL_ROW_19_480 VGND VPWR sky130_fd_sc_hd__tapvpwrvgnd_1
XFILLER_24_477 VGND VGND VPWR VPWR sky130_fd_sc_hd__decap_8
X_4969_ _0711_ _0725_ VGND VGND VPWR VPWR _0727_ sky130_fd_sc_hd__nand2_1
XFILLER_11_138 VGND VGND VPWR VPWR sky130_fd_sc_hd__fill_2
X_6708_ net438 net205 net198 net440 VGND VGND VPWR VPWR _2621_ sky130_fd_sc_hd__a22oi_1
X_6639_ _2350_ _2353_ _2543_ VGND VGND VPWR VPWR _2545_ sky130_fd_sc_hd__and3_1
XTAP_TAPCELL_ROW_115_1633 VGND VPWR sky130_fd_sc_hd__tapvpwrvgnd_1
XFILLER_98_27 VGND VGND VPWR VPWR sky130_fd_sc_hd__fill_1
XFILLER_105_221 VGND VGND VPWR VPWR sky130_fd_sc_hd__decap_3
XFILLER_3_337 VPWR VGND VPWR VGND sky130_ef_sc_hd__decap_12
XFILLER_105_276 VGND VGND VPWR VPWR sky130_fd_sc_hd__decap_4
XFILLER_79_617 VPWR VGND VPWR VGND sky130_ef_sc_hd__decap_12
XPHY_EDGE_ROW_110_Right_110 VGND VGND VPWR VPWR sky130_fd_sc_hd__decap_3
XFILLER_78_127 VPWR VGND VPWR VGND sky130_ef_sc_hd__decap_12
Xfanout140 _1964_ VGND VGND VPWR VPWR net140 sky130_fd_sc_hd__clkbuf_4
Xfanout151 net156 VGND VGND VPWR VPWR net151 sky130_fd_sc_hd__buf_2
XFILLER_59_363 VGND VGND VPWR VPWR sky130_fd_sc_hd__decap_8
XFILLER_19_205 VGND VGND VPWR VPWR sky130_fd_sc_hd__fill_2
Xfanout173 net8 VGND VGND VPWR VPWR net173 sky130_fd_sc_hd__clkbuf_4
Xfanout162 _0787_ VGND VGND VPWR VPWR net162 sky130_fd_sc_hd__clkbuf_4
Xfanout195 net196 VGND VGND VPWR VPWR net195 sky130_fd_sc_hd__dlymetal6s2s_1
Xfanout184 net65 VGND VGND VPWR VPWR net184 sky130_fd_sc_hd__buf_2
XFILLER_74_388 VGND VGND VPWR VPWR sky130_fd_sc_hd__decap_8
XFILLER_27_260 VGND VGND VPWR VPWR sky130_fd_sc_hd__decap_3
XFILLER_34_208 VPWR VGND VPWR VGND sky130_ef_sc_hd__decap_12
XFILLER_103_81 VPWR VGND VPWR VGND sky130_ef_sc_hd__decap_12
XFILLER_27_293 VPWR VGND VPWR VGND sky130_ef_sc_hd__decap_12
XFILLER_30_403 VPWR VGND VPWR VGND sky130_ef_sc_hd__decap_12
XFILLER_7_665 VGND VGND VPWR VPWR sky130_fd_sc_hd__decap_6
XFILLER_6_197 VGND VGND VPWR VPWR sky130_fd_sc_hd__fill_1
XTAP_TAPCELL_ROW_90_1327 VGND VPWR sky130_fd_sc_hd__tapvpwrvgnd_1
XFILLER_111_246 VGND VGND VPWR VPWR sky130_fd_sc_hd__decap_4
XFILLER_97_447 VGND VGND VPWR VPWR sky130_fd_sc_hd__fill_1
XFILLER_85_609 VGND VGND VPWR VPWR sky130_fd_sc_hd__decap_6
XFILLER_111_279 VGND VGND VPWR VPWR sky130_fd_sc_hd__fill_1
XFILLER_84_108 VPWR VGND VPWR VGND sky130_ef_sc_hd__decap_12
XFILLER_19_3 VPWR VGND VPWR VGND sky130_ef_sc_hd__decap_12
XFILLER_93_653 VPWR VGND VPWR VGND sky130_ef_sc_hd__decap_12
XFILLER_65_388 VGND VGND VPWR VPWR sky130_fd_sc_hd__decap_4
XFILLER_53_539 VPWR VGND VPWR VGND sky130_ef_sc_hd__decap_12
X_5941_ _1638_ _1640_ VGND VGND VPWR VPWR _1784_ sky130_fd_sc_hd__nand2_1
XFILLER_61_561 VGND VGND VPWR VPWR sky130_fd_sc_hd__decap_8
X_5872_ _1565_ _1567_ _1706_ _1708_ VGND VGND VPWR VPWR _1709_ sky130_fd_sc_hd__a211o_1
X_4823_ net380 net373 net211 net203 VGND VGND VPWR VPWR _0583_ sky130_fd_sc_hd__nand4_2
XTAP_TAPCELL_ROW_44_781 VGND VPWR sky130_fd_sc_hd__tapvpwrvgnd_1
X_4754_ _0512_ _0513_ _0506_ VGND VGND VPWR VPWR _0515_ sky130_fd_sc_hd__a21o_1
X_3705_ _1135_ _2893_ _2905_ net139 VGND VGND VPWR VPWR _2906_ sky130_fd_sc_hd__a211o_1
X_4685_ _0444_ _0445_ _0349_ VGND VGND VPWR VPWR _0447_ sky130_fd_sc_hd__a21o_1
XFILLER_108_15 VPWR VGND VPWR VGND sky130_ef_sc_hd__decap_12
X_3636_ _2831_ _2835_ _2838_ _1572_ _2839_ VGND VGND VPWR VPWR _2840_ sky130_fd_sc_hd__o221a_1
X_6424_ _2263_ _2264_ _2309_ VGND VGND VPWR VPWR _2311_ sky130_fd_sc_hd__o21a_1
XFILLER_115_541 VPWR VGND VPWR VGND sky130_ef_sc_hd__decap_12
X_3567_ _1441_ _1473_ net279 VGND VGND VPWR VPWR _2531_ sky130_fd_sc_hd__mux2_1
X_6355_ _2075_ _2077_ _2074_ VGND VGND VPWR VPWR _2235_ sky130_fd_sc_hd__o21ba_1
XFILLER_115_585 VPWR VGND VPWR VGND sky130_ef_sc_hd__decap_12
XFILLER_88_425 VGND VGND VPWR VPWR sky130_fd_sc_hd__fill_1
X_5306_ _0903_ _0905_ _1089_ _1090_ VGND VGND VPWR VPWR _1091_ sky130_fd_sc_hd__a211oi_2
X_6286_ _2157_ _2158_ _1947_ _1999_ VGND VGND VPWR VPWR _2160_ sky130_fd_sc_hd__a211oi_1
X_5237_ net433 net194 _0943_ _0942_ VGND VGND VPWR VPWR _1016_ sky130_fd_sc_hd__a31o_1
X_3498_ net349 net456 VGND VGND VPWR VPWR _1779_ sky130_fd_sc_hd__nand2_1
XFILLER_0_329 VGND VGND VPWR VPWR sky130_fd_sc_hd__fill_1
XTAP_TAPCELL_ROW_110_1574 VGND VPWR sky130_fd_sc_hd__tapvpwrvgnd_1
XFILLER_102_246 VGND VGND VPWR VPWR sky130_fd_sc_hd__decap_6
XFILLER_84_620 VPWR VGND VPWR VGND sky130_ef_sc_hd__decap_12
XFILLER_84_29 VPWR VGND VPWR VGND sky130_ef_sc_hd__decap_12
X_5168_ net433 net192 VGND VGND VPWR VPWR _0941_ sky130_fd_sc_hd__nand2_1
XFILLER_68_171 VGND VGND VPWR VPWR sky130_fd_sc_hd__decap_8
XFILLER_29_536 VPWR VGND VPWR VGND sky130_ef_sc_hd__decap_12
X_5099_ _0862_ _0864_ _0760_ _0762_ VGND VGND VPWR VPWR _0866_ sky130_fd_sc_hd__o211ai_2
X_4119_ _3285_ _3299_ _3301_ VGND VGND VPWR VPWR _3302_ sky130_fd_sc_hd__a21oi_1
XFILLER_56_388 VGND VGND VPWR VPWR sky130_fd_sc_hd__fill_2
XFILLER_71_358 VGND VGND VPWR VPWR sky130_fd_sc_hd__decap_4
XTAP_TAPCELL_ROW_65_1031 VGND VPWR sky130_fd_sc_hd__tapvpwrvgnd_1
XFILLER_17_89 VPWR VGND VPWR VGND sky130_ef_sc_hd__decap_12
XFILLER_52_561 VGND VGND VPWR VPWR sky130_fd_sc_hd__decap_6
XFILLER_52_550 VGND VGND VPWR VPWR sky130_fd_sc_hd__decap_4
XFILLER_12_469 VGND VGND VPWR VPWR sky130_fd_sc_hd__decap_6
XFILLER_8_418 VGND VGND VPWR VPWR sky130_fd_sc_hd__fill_2
XFILLER_33_55 VGND VGND VPWR VPWR sky130_fd_sc_hd__fill_1
XFILLER_4_613 VPWR VGND VPWR VGND sky130_ef_sc_hd__decap_12
XTAP_TAPCELL_ROW_76_1160 VGND VPWR sky130_fd_sc_hd__tapvpwrvgnd_1
XFILLER_4_657 VPWR VGND VPWR VGND sky130_ef_sc_hd__decap_12
XFILLER_66_108 VGND VGND VPWR VPWR sky130_fd_sc_hd__decap_8
XFILLER_58_41 VPWR VGND VPWR VGND sky130_ef_sc_hd__decap_12
XFILLER_58_85 VGND VGND VPWR VPWR sky130_fd_sc_hd__decap_8
XFILLER_75_653 VPWR VGND VPWR VGND sky130_ef_sc_hd__decap_12
XFILLER_90_601 VPWR VGND VPWR VGND sky130_ef_sc_hd__decap_12
XFILLER_74_51 VGND VGND VPWR VPWR sky130_fd_sc_hd__decap_4
XFILLER_47_366 VPWR VGND VPWR VGND sky130_ef_sc_hd__decap_12
XFILLER_90_645 VPWR VGND VPWR VGND sky130_ef_sc_hd__decap_12
XFILLER_28_580 VGND VGND VPWR VPWR sky130_fd_sc_hd__decap_8
XFILLER_90_689 VGND VGND VPWR VPWR sky130_fd_sc_hd__decap_3
XFILLER_43_561 VGND VGND VPWR VPWR sky130_fd_sc_hd__decap_4
XFILLER_50_509 VGND VGND VPWR VPWR sky130_fd_sc_hd__decap_4
XFILLER_90_61 VPWR VGND VPWR VGND sky130_ef_sc_hd__decap_12
XFILLER_30_244 VGND VGND VPWR VPWR sky130_fd_sc_hd__decap_4
XTAP_TAPCELL_ROW_41_740 VGND VPWR sky130_fd_sc_hd__tapvpwrvgnd_1
XFILLER_116_305 VGND VGND VPWR VPWR sky130_fd_sc_hd__decap_3
X_4470_ net455 net196 net191 net472 VGND VGND VPWR VPWR _0235_ sky130_fd_sc_hd__a22oi_1
Xmax_cap115 _1077_ VGND VGND VPWR VPWR net115 sky130_fd_sc_hd__clkbuf_1
XFILLER_116_349 VGND VGND VPWR VPWR sky130_fd_sc_hd__decap_3
X_3421_ net321 VGND VGND VPWR VPWR _0939_ sky130_fd_sc_hd__inv_2
X_6140_ _1799_ _1846_ net109 _2000_ VGND VGND VPWR VPWR _2001_ sky130_fd_sc_hd__a211o_2
XFILLER_112_533 VPWR VGND VPWR VGND sky130_ef_sc_hd__decap_12
XFILLER_85_417 VGND VGND VPWR VPWR sky130_fd_sc_hd__fill_1
X_6071_ net309 net319 _1923_ _1924_ VGND VGND VPWR VPWR _1925_ sky130_fd_sc_hd__nand4_1
X_5022_ _0779_ _0780_ _0781_ VGND VGND VPWR VPWR _0782_ sky130_fd_sc_hd__or3b_2
XFILLER_38_333 VGND VGND VPWR VPWR sky130_fd_sc_hd__decap_4
XTAP_TAPCELL_ROW_49_840 VGND VPWR sky130_fd_sc_hd__tapvpwrvgnd_1
XFILLER_38_377 VPWR VGND VPWR VGND sky130_ef_sc_hd__decap_12
X_5924_ net5 net330 net324 net4 VGND VGND VPWR VPWR _1765_ sky130_fd_sc_hd__a22o_1
XFILLER_110_27 VGND VGND VPWR VPWR sky130_fd_sc_hd__fill_1
X_5855_ _1686_ _1687_ _1675_ VGND VGND VPWR VPWR _1690_ sky130_fd_sc_hd__a21oi_1
X_4806_ net227 net433 net386 net240 VGND VGND VPWR VPWR _0566_ sky130_fd_sc_hd__a22o_1
XFILLER_61_391 VGND VGND VPWR VPWR sky130_fd_sc_hd__fill_1
XFILLER_21_222 VGND VGND VPWR VPWR sky130_fd_sc_hd__fill_2
XFILLER_21_244 VGND VGND VPWR VPWR sky130_fd_sc_hd__decap_3
X_5786_ net219 net175 net186 net341 VGND VGND VPWR VPWR _1614_ sky130_fd_sc_hd__and4_1
X_4737_ _0494_ _0495_ _0496_ VGND VGND VPWR VPWR _0498_ sky130_fd_sc_hd__a21oi_1
X_4668_ _0420_ _0429_ VGND VGND VPWR VPWR _0430_ sky130_fd_sc_hd__xnor2_1
X_3619_ _2822_ VGND VGND VPWR VPWR _2823_ sky130_fd_sc_hd__inv_2
X_6407_ _2283_ _2291_ VGND VGND VPWR VPWR _2293_ sky130_fd_sc_hd__nand2_1
X_4599_ _0359_ _0360_ _0361_ VGND VGND VPWR VPWR _0362_ sky130_fd_sc_hd__nand3_1
XFILLER_115_393 VPWR VGND VPWR VGND sky130_ef_sc_hd__decap_12
XFILLER_115_371 VGND VGND VPWR VPWR sky130_fd_sc_hd__decap_8
XFILLER_103_522 VPWR VGND VPWR VGND sky130_ef_sc_hd__decap_12
X_6338_ _2028_ _2214_ VGND VGND VPWR VPWR _2217_ sky130_fd_sc_hd__and2_1
XFILLER_95_39 VGND VGND VPWR VPWR sky130_fd_sc_hd__decap_8
XFILLER_0_137 VGND VGND VPWR VPWR sky130_fd_sc_hd__decap_3
X_6269_ _2129_ _2140_ _2141_ VGND VGND VPWR VPWR _2142_ sky130_fd_sc_hd__and3_2
XFILLER_88_277 VGND VGND VPWR VPWR sky130_fd_sc_hd__fill_2
XFILLER_84_450 VPWR VGND VPWR VGND sky130_ef_sc_hd__decap_12
XFILLER_72_601 VGND VGND VPWR VPWR sky130_fd_sc_hd__decap_4
XFILLER_56_174 VGND VGND VPWR VPWR sky130_fd_sc_hd__fill_1
XFILLER_56_141 VGND VGND VPWR VPWR sky130_fd_sc_hd__decap_8
XFILLER_28_77 VGND VGND VPWR VPWR sky130_fd_sc_hd__decap_6
XFILLER_72_645 VPWR VGND VPWR VGND sky130_ef_sc_hd__decap_12
XFILLER_71_111 VGND VGND VPWR VPWR sky130_fd_sc_hd__fill_1
XFILLER_72_689 VGND VGND VPWR VPWR sky130_fd_sc_hd__decap_3
XTAP_TAPCELL_ROW_27_578 VGND VPWR sky130_fd_sc_hd__tapvpwrvgnd_1
XFILLER_100_82 VGND VGND VPWR VPWR sky130_fd_sc_hd__fill_2
XFILLER_8_204 VPWR VGND VPWR VGND sky130_ef_sc_hd__decap_12
XFILLER_40_586 VGND VGND VPWR VPWR sky130_fd_sc_hd__fill_2
XFILLER_60_97 VPWR VGND VPWR VGND sky130_ef_sc_hd__decap_12
XFILLER_5_15 VPWR VGND VPWR VGND sky130_ef_sc_hd__decap_12
XFILLER_4_421 VPWR VGND VPWR VGND sky130_ef_sc_hd__decap_12
XFILLER_106_382 VGND VGND VPWR VPWR sky130_fd_sc_hd__decap_8
XFILLER_79_211 VPWR VGND VPWR VGND sky130_ef_sc_hd__decap_12
XFILLER_67_428 VGND VGND VPWR VPWR sky130_fd_sc_hd__fill_1
XFILLER_94_269 VPWR VGND VPWR VGND sky130_ef_sc_hd__decap_12
XPHY_EDGE_ROW_13_Right_13 VGND VGND VPWR VPWR sky130_fd_sc_hd__decap_3
XFILLER_85_72 VGND VGND VPWR VPWR sky130_fd_sc_hd__fill_2
XFILLER_35_303 VGND VGND VPWR VPWR sky130_fd_sc_hd__decap_4
XFILLER_35_314 VPWR VGND VPWR VGND sky130_ef_sc_hd__decap_12
X_3970_ _3157_ _3159_ _3152_ VGND VGND VPWR VPWR _alu_i0.Datapath_i.fu_alu_33673_33851.out1\[17\]
+ sky130_fd_sc_hd__or3b_1
XFILLER_86_3 VPWR VGND VPWR VGND sky130_ef_sc_hd__decap_12
X_5640_ _1208_ _1333_ VGND VGND VPWR VPWR _1456_ sky130_fd_sc_hd__or2_1
X_5571_ net453 net272 net269 net469 VGND VGND VPWR VPWR _1380_ sky130_fd_sc_hd__a22o_1
XPHY_EDGE_ROW_22_Right_22 VGND VGND VPWR VPWR sky130_fd_sc_hd__decap_3
XFILLER_116_113 VPWR VGND VPWR VGND sky130_ef_sc_hd__decap_12
X_4522_ _0284_ _0286_ net149 VGND VGND VPWR VPWR _0287_ sky130_fd_sc_hd__a21oi_1
X_4453_ net472 net196 _0217_ _0218_ VGND VGND VPWR VPWR _0219_ sky130_fd_sc_hd__and4_1
XFILLER_7_281 VGND VGND VPWR VPWR sky130_fd_sc_hd__decap_8
XFILLER_116_179 VGND VGND VPWR VPWR sky130_fd_sc_hd__fill_1
XTAP_TAPCELL_ROW_96_1399 VGND VPWR sky130_fd_sc_hd__tapvpwrvgnd_1
XFILLER_98_531 VGND VGND VPWR VPWR sky130_fd_sc_hd__fill_1
X_4384_ _alu_i0.Datapath_i.reg_0.reg_out1\[6\] _0151_ net148 VGND VGND VPWR VPWR net105
+ sky130_fd_sc_hd__mux2_1
X_6123_ _1981_ VGND VGND VPWR VPWR _1982_ sky130_fd_sc_hd__inv_2
XFILLER_105_27 VPWR VGND VPWR VGND sky130_ef_sc_hd__decap_12
X_6054_ net465 net193 VGND VGND VPWR VPWR _1906_ sky130_fd_sc_hd__nand2_1
XPHY_EDGE_ROW_31_Right_31 VGND VGND VPWR VPWR sky130_fd_sc_hd__decap_3
XFILLER_100_569 VPWR VGND VPWR VGND sky130_ef_sc_hd__decap_12
X_5005_ _0759_ _0761_ _0668_ _0670_ VGND VGND VPWR VPWR _0763_ sky130_fd_sc_hd__o211ai_2
XFILLER_39_653 VPWR VGND VPWR VGND sky130_ef_sc_hd__decap_12
XFILLER_54_601 VGND VGND VPWR VPWR sky130_fd_sc_hd__decap_8
XFILLER_38_141 VGND VGND VPWR VPWR sky130_fd_sc_hd__decap_8
XFILLER_54_645 VPWR VGND VPWR VGND sky130_ef_sc_hd__decap_12
XFILLER_54_634 VGND VGND VPWR VPWR sky130_fd_sc_hd__decap_8
XFILLER_53_133 VGND VGND VPWR VPWR sky130_fd_sc_hd__decap_3
XFILLER_81_497 VGND VGND VPWR VPWR sky130_fd_sc_hd__decap_6
XTAP_TAPCELL_ROW_62_1001 VGND VPWR sky130_fd_sc_hd__tapvpwrvgnd_1
X_5907_ net375 net297 net293 net388 VGND VGND VPWR VPWR _1747_ sky130_fd_sc_hd__a22o_1
XFILLER_41_317 VGND VGND VPWR VPWR sky130_fd_sc_hd__decap_8
X_6887_ net181 _alu_i0.Datapath_i.fu_alu_33673_33851.out1\[13\] VGND VGND VPWR VPWR
+ _alu_i0.Datapath_i.reg_0.reg_out1\[13\] sky130_fd_sc_hd__dfxtp_1
XTAP_TAPCELL_ROW_24_537 VGND VPWR sky130_fd_sc_hd__tapvpwrvgnd_1
XTAP_TAPCELL_ROW_52_879 VGND VPWR sky130_fd_sc_hd__tapvpwrvgnd_1
XPHY_EDGE_ROW_40_Right_40 VGND VGND VPWR VPWR sky130_fd_sc_hd__decap_3
X_5838_ _1668_ _1669_ VGND VGND VPWR VPWR _1672_ sky130_fd_sc_hd__xnor2_1
X_5769_ _1464_ _1466_ _1463_ VGND VGND VPWR VPWR _1596_ sky130_fd_sc_hd__o21ba_1
XFILLER_108_625 VPWR VGND VPWR VGND sky130_ef_sc_hd__decap_12
XFILLER_5_207 VPWR VGND VPWR VGND sky130_ef_sc_hd__decap_12
XFILLER_108_669 VPWR VGND VPWR VGND sky130_ef_sc_hd__decap_12
XFILLER_107_113 VPWR VGND VPWR VGND sky130_ef_sc_hd__decap_12
XFILLER_116_691 VGND VGND VPWR VPWR sky130_fd_sc_hd__fill_1
XTAP_TAPCELL_ROW_73_1130 VGND VPWR sky130_fd_sc_hd__tapvpwrvgnd_1
XFILLER_49_406 VGND VGND VPWR VPWR sky130_fd_sc_hd__fill_1
XFILLER_89_597 VPWR VGND VPWR VGND sky130_ef_sc_hd__decap_12
XFILLER_76_225 VGND VGND VPWR VPWR sky130_fd_sc_hd__fill_2
XFILLER_39_65 VGND VGND VPWR VPWR sky130_fd_sc_hd__decap_3
XTAP_TAPCELL_ROW_4_295 VGND VPWR sky130_fd_sc_hd__tapvpwrvgnd_1
XFILLER_111_81 VPWR VGND VPWR VGND sky130_ef_sc_hd__decap_12
XFILLER_13_597 VPWR VGND VPWR VGND sky130_ef_sc_hd__decap_12
XFILLER_40_394 VGND VGND VPWR VPWR sky130_fd_sc_hd__decap_3
XFILLER_99_317 VGND VGND VPWR VPWR sky130_fd_sc_hd__fill_1
XFILLER_4_251 VGND VGND VPWR VPWR sky130_fd_sc_hd__fill_1
XFILLER_113_105 VGND VGND VPWR VPWR sky130_fd_sc_hd__decap_6
XFILLER_107_691 VGND VGND VPWR VPWR sky130_fd_sc_hd__fill_1
XFILLER_4_273 VGND VGND VPWR VPWR sky130_fd_sc_hd__fill_2
XFILLER_67_214 VGND VGND VPWR VPWR sky130_fd_sc_hd__decap_8
XFILLER_67_269 VGND VGND VPWR VPWR sky130_fd_sc_hd__fill_1
XFILLER_36_645 VPWR VGND VPWR VGND sky130_ef_sc_hd__decap_12
X_6810_ _2341_ _2506_ _2523_ VGND VGND VPWR VPWR _2732_ sky130_fd_sc_hd__o21a_1
XFILLER_63_486 VPWR VGND VPWR VGND sky130_ef_sc_hd__decap_12
XFILLER_23_317 VPWR VGND VPWR VGND sky130_ef_sc_hd__decap_12
XFILLER_36_689 VGND VGND VPWR VPWR sky130_fd_sc_hd__decap_3
X_6741_ _2485_ _2487_ VGND VGND VPWR VPWR _2657_ sky130_fd_sc_hd__nor2_1
X_3953_ _3141_ _3142_ VGND VGND VPWR VPWR _3143_ sky130_fd_sc_hd__and2_1
X_3884_ _3075_ _3076_ VGND VGND VPWR VPWR _3077_ sky130_fd_sc_hd__nand2_1
XTAP_TAPCELL_ROW_21_507 VGND VPWR sky130_fd_sc_hd__tapvpwrvgnd_1
X_6672_ _2579_ _2580_ VGND VGND VPWR VPWR _2581_ sky130_fd_sc_hd__or2_1
XTAP_TAPCELL_ROW_98_1428 VGND VPWR sky130_fd_sc_hd__tapvpwrvgnd_1
X_5623_ _1313_ _1434_ _1435_ VGND VGND VPWR VPWR _1437_ sky130_fd_sc_hd__nand3_1
X_5554_ _1356_ _1359_ _1360_ VGND VGND VPWR VPWR _1361_ sky130_fd_sc_hd__nand3_2
X_4505_ _0267_ _0268_ _0215_ VGND VGND VPWR VPWR _0270_ sky130_fd_sc_hd__a21o_1
XFILLER_105_617 VPWR VGND VPWR VGND sky130_ef_sc_hd__decap_12
X_5485_ _1280_ _1281_ _1283_ VGND VGND VPWR VPWR _1286_ sky130_fd_sc_hd__or3b_1
XFILLER_116_15 VPWR VGND VPWR VGND sky130_ef_sc_hd__decap_12
X_4436_ net249 net391 VGND VGND VPWR VPWR _0202_ sky130_fd_sc_hd__and2_1
X_4367_ net355 net391 _0133_ _0134_ VGND VGND VPWR VPWR _0135_ sky130_fd_sc_hd__a22o_1
X_6106_ _1960_ _1961_ VGND VGND VPWR VPWR _1963_ sky130_fd_sc_hd__xor2_1
X_4298_ _0068_ VGND VGND VPWR VPWR _0069_ sky130_fd_sc_hd__inv_2
XFILLER_86_545 VGND VGND VPWR VPWR sky130_fd_sc_hd__decap_6
XFILLER_86_589 VPWR VGND VPWR VGND sky130_ef_sc_hd__decap_12
XFILLER_73_206 VGND VGND VPWR VPWR sky130_fd_sc_hd__decap_8
XFILLER_58_269 VPWR VGND VPWR VGND sky130_ef_sc_hd__decap_12
X_6037_ net388 net275 _1884_ _1885_ VGND VGND VPWR VPWR _1888_ sky130_fd_sc_hd__a22o_1
XTAP_TAPCELL_ROW_57_938 VGND VPWR sky130_fd_sc_hd__tapvpwrvgnd_1
XFILLER_39_494 VGND VGND VPWR VPWR sky130_fd_sc_hd__decap_8
XTAP_TAPCELL_ROW_107_1535 VGND VPWR sky130_fd_sc_hd__tapvpwrvgnd_1
XFILLER_92_29 VPWR VGND VPWR VGND sky130_ef_sc_hd__decap_12
XFILLER_54_453 VPWR VGND VPWR VGND sky130_ef_sc_hd__decap_12
XFILLER_54_431 VPWR VGND VPWR VGND sky130_ef_sc_hd__decap_12
XTAP_TAPCELL_ROW_1_265 VGND VPWR sky130_fd_sc_hd__tapvpwrvgnd_1
XTAP_TAPCELL_ROW_37_695 VGND VPWR sky130_fd_sc_hd__tapvpwrvgnd_1
XFILLER_41_169 VGND VGND VPWR VPWR sky130_fd_sc_hd__decap_8
XFILLER_50_681 VGND VGND VPWR VPWR sky130_fd_sc_hd__decap_8
XFILLER_10_545 VPWR VGND VPWR VGND sky130_ef_sc_hd__decap_12
XFILLER_10_589 VPWR VGND VPWR VGND sky130_ef_sc_hd__decap_12
XFILLER_108_477 VGND VGND VPWR VPWR sky130_fd_sc_hd__fill_1
XFILLER_111_609 VGND VGND VPWR VPWR sky130_fd_sc_hd__decap_6
XTAP_TAPCELL_ROW_9_365 VGND VPWR sky130_fd_sc_hd__tapvpwrvgnd_1
XTAP_TAPCELL_ROW_9_354 VGND VPWR sky130_fd_sc_hd__tapvpwrvgnd_1
XFILLER_110_119 VPWR VGND VPWR VGND sky130_ef_sc_hd__decap_12
XFILLER_106_81 VGND VGND VPWR VPWR sky130_fd_sc_hd__decap_3
XFILLER_2_27 VGND VGND VPWR VPWR sky130_fd_sc_hd__fill_1
XFILLER_49_225 VPWR VGND VPWR VGND sky130_ef_sc_hd__decap_12
XFILLER_77_567 VGND VGND VPWR VPWR sky130_fd_sc_hd__fill_1
XFILLER_18_601 VPWR VGND VPWR VGND sky130_ef_sc_hd__decap_12
XFILLER_64_217 VGND VGND VPWR VPWR sky130_fd_sc_hd__decap_4
XFILLER_18_645 VPWR VGND VPWR VGND sky130_ef_sc_hd__decap_12
XFILLER_45_420 VGND VGND VPWR VPWR sky130_fd_sc_hd__fill_1
XFILLER_33_615 VGND VGND VPWR VPWR sky130_fd_sc_hd__fill_1
XFILLER_32_125 VPWR VGND VPWR VGND sky130_ef_sc_hd__decap_12
XFILLER_32_147 VGND VGND VPWR VPWR sky130_fd_sc_hd__decap_8
XFILLER_9_321 VGND VGND VPWR VPWR sky130_fd_sc_hd__decap_8
XFILLER_70_6 VPWR VGND VPWR VGND sky130_ef_sc_hd__decap_12
XFILLER_9_387 VGND VGND VPWR VPWR sky130_fd_sc_hd__fill_1
Xoutput106 net106 VGND VGND VPWR VPWR return_port[7] sky130_fd_sc_hd__clkbuf_4
XFILLER_114_414 VGND VGND VPWR VPWR sky130_fd_sc_hd__decap_6
X_5270_ _1050_ _1051_ _1049_ VGND VGND VPWR VPWR _1052_ sky130_fd_sc_hd__a21o_1
XFILLER_114_469 VGND VGND VPWR VPWR sky130_fd_sc_hd__decap_6
XTAP_TAPCELL_ROW_93_1369 VGND VPWR sky130_fd_sc_hd__tapvpwrvgnd_1
X_4221_ _3393_ _3397_ _3398_ VGND VGND VPWR VPWR _3399_ sky130_fd_sc_hd__a21oi_1
X_4152_ _3331_ _3332_ VGND VGND VPWR VPWR _3333_ sky130_fd_sc_hd__and2_1
XFILLER_95_375 VGND VGND VPWR VPWR sky130_fd_sc_hd__decap_3
XFILLER_68_589 VPWR VGND VPWR VGND sky130_ef_sc_hd__decap_12
XFILLER_68_578 VGND VGND VPWR VPWR sky130_fd_sc_hd__decap_8
XFILLER_28_409 VGND VGND VPWR VPWR sky130_fd_sc_hd__decap_8
X_4083_ _0863_ net270 VGND VGND VPWR VPWR _3267_ sky130_fd_sc_hd__or2_1
XFILLER_91_581 VPWR VGND VPWR VGND sky130_ef_sc_hd__decap_12
XFILLER_63_272 VGND VGND VPWR VPWR sky130_fd_sc_hd__decap_8
XFILLER_24_637 VGND VGND VPWR VPWR sky130_fd_sc_hd__decap_6
XFILLER_36_464 VGND VGND VPWR VPWR sky130_fd_sc_hd__fill_2
X_4985_ _0733_ _0742_ VGND VGND VPWR VPWR _0743_ sky130_fd_sc_hd__xnor2_1
XFILLER_23_125 VPWR VGND VPWR VGND sky130_ef_sc_hd__decap_12
X_3936_ _3031_ _3033_ _3057_ _3125_ VGND VGND VPWR VPWR _3127_ sky130_fd_sc_hd__o31a_1
XFILLER_23_158 VGND VGND VPWR VPWR sky130_fd_sc_hd__decap_8
X_6724_ _2636_ _2637_ VGND VGND VPWR VPWR _2638_ sky130_fd_sc_hd__nand2_1
XTAP_TAPCELL_ROW_34_654 VGND VPWR sky130_fd_sc_hd__tapvpwrvgnd_1
XTAP_TAPCELL_ROW_34_665 VGND VPWR sky130_fd_sc_hd__tapvpwrvgnd_1
XTAP_TAPCELL_ROW_102_1476 VGND VPWR sky130_fd_sc_hd__tapvpwrvgnd_1
XTAP_TAPCELL_ROW_62_996 VGND VPWR sky130_fd_sc_hd__tapvpwrvgnd_1
XFILLER_32_681 VGND VGND VPWR VPWR sky130_fd_sc_hd__decap_8
XFILLER_109_208 VPWR VGND VPWR VGND sky130_ef_sc_hd__decap_12
X_3867_ net135 _3060_ VGND VGND VPWR VPWR _3061_ sky130_fd_sc_hd__nand2_1
X_6655_ net464 net329 net323 net166 VGND VGND VPWR VPWR _2562_ sky130_fd_sc_hd__a22o_1
X_3798_ net130 _2983_ _2993_ _2994_ _1550_ VGND VGND VPWR VPWR _2995_ sky130_fd_sc_hd__o221a_1
X_5606_ net368 net322 _1415_ _1416_ VGND VGND VPWR VPWR _1418_ sky130_fd_sc_hd__nand4_1
X_6586_ _2485_ _2486_ _2278_ _2280_ VGND VGND VPWR VPWR _2488_ sky130_fd_sc_hd__o211a_1
X_5537_ net248 net463 _1215_ _1216_ net467 VGND VGND VPWR VPWR _1343_ sky130_fd_sc_hd__a32o_1
XFILLER_105_469 VGND VGND VPWR VPWR sky130_fd_sc_hd__decap_8
X_5468_ _1263_ _1267_ VGND VGND VPWR VPWR _1268_ sky130_fd_sc_hd__xnor2_1
X_4419_ _0184_ _0185_ VGND VGND VPWR VPWR _0186_ sky130_fd_sc_hd__xnor2_1
Xfanout311 net312 VGND VGND VPWR VPWR net311 sky130_fd_sc_hd__buf_2
X_5399_ _1191_ _1192_ _1077_ VGND VGND VPWR VPWR _1193_ sky130_fd_sc_hd__nor3b_2
XTAP_TAPCELL_ROW_6_324 VGND VPWR sky130_fd_sc_hd__tapvpwrvgnd_1
Xfanout322 net38 VGND VGND VPWR VPWR net322 sky130_fd_sc_hd__buf_2
Xfanout300 net42 VGND VGND VPWR VPWR net300 sky130_fd_sc_hd__buf_1
Xfanout344 net345 VGND VGND VPWR VPWR net344 sky130_fd_sc_hd__buf_2
Xfanout355 net358 VGND VGND VPWR VPWR net355 sky130_fd_sc_hd__clkbuf_4
Xfanout333 net36 VGND VGND VPWR VPWR net333 sky130_fd_sc_hd__buf_2
Xfanout366 net32 VGND VGND VPWR VPWR net366 sky130_fd_sc_hd__clkbuf_4
XFILLER_101_653 VPWR VGND VPWR VGND sky130_ef_sc_hd__decap_12
XFILLER_100_141 VPWR VGND VPWR VGND sky130_ef_sc_hd__decap_12
Xfanout377 net378 VGND VGND VPWR VPWR net377 sky130_fd_sc_hd__buf_2
XFILLER_86_353 VGND VGND VPWR VPWR sky130_fd_sc_hd__decap_4
Xfanout399 net400 VGND VGND VPWR VPWR net399 sky130_fd_sc_hd__buf_2
XFILLER_74_504 VGND VGND VPWR VPWR sky130_fd_sc_hd__decap_3
Xfanout388 net389 VGND VGND VPWR VPWR net388 sky130_fd_sc_hd__clkbuf_4
XFILLER_19_409 VPWR VGND VPWR VGND sky130_ef_sc_hd__decap_12
XFILLER_74_526 VGND VGND VPWR VPWR sky130_fd_sc_hd__decap_6
XFILLER_46_228 VGND VGND VPWR VPWR sky130_fd_sc_hd__fill_2
XFILLER_46_239 VGND VGND VPWR VPWR sky130_fd_sc_hd__decap_4
XFILLER_82_581 VGND VGND VPWR VPWR sky130_fd_sc_hd__decap_6
XTAP_TAPCELL_ROW_68_1073 VGND VPWR sky130_fd_sc_hd__tapvpwrvgnd_1
XTAP_TAPCELL_ROW_68_1062 VGND VPWR sky130_fd_sc_hd__tapvpwrvgnd_1
XFILLER_15_615 VGND VGND VPWR VPWR sky130_fd_sc_hd__fill_1
XFILLER_36_77 VGND VGND VPWR VPWR sky130_fd_sc_hd__decap_4
XFILLER_42_412 VGND VGND VPWR VPWR sky130_fd_sc_hd__decap_8
XFILLER_42_434 VGND VGND VPWR VPWR sky130_fd_sc_hd__fill_1
XFILLER_52_65 VGND VGND VPWR VPWR sky130_fd_sc_hd__decap_6
Xinput19 a[26] VGND VGND VPWR VPWR net19 sky130_fd_sc_hd__clkbuf_2
XFILLER_6_324 VGND VGND VPWR VPWR sky130_fd_sc_hd__fill_2
XFILLER_6_346 VGND VGND VPWR VPWR sky130_fd_sc_hd__decap_4
XFILLER_108_296 VGND VGND VPWR VPWR sky130_fd_sc_hd__decap_4
XFILLER_111_417 VPWR VGND VPWR VGND sky130_ef_sc_hd__decap_12
XFILLER_97_629 VPWR VGND VPWR VGND sky130_ef_sc_hd__decap_12
XFILLER_104_491 VPWR VGND VPWR VGND sky130_ef_sc_hd__decap_12
XFILLER_77_73 VGND VGND VPWR VPWR sky130_fd_sc_hd__fill_2
XFILLER_77_364 VPWR VGND VPWR VGND sky130_ef_sc_hd__decap_12
XFILLER_77_95 VGND VGND VPWR VPWR sky130_fd_sc_hd__decap_4
XFILLER_37_206 VGND VGND VPWR VPWR sky130_fd_sc_hd__decap_4
XFILLER_65_559 VGND VGND VPWR VPWR sky130_fd_sc_hd__fill_1
XFILLER_45_261 VGND VGND VPWR VPWR sky130_fd_sc_hd__fill_1
XFILLER_60_231 VGND VGND VPWR VPWR sky130_fd_sc_hd__fill_1
XFILLER_60_253 VGND VGND VPWR VPWR sky130_fd_sc_hd__decap_6
XFILLER_21_629 VPWR VGND VPWR VGND sky130_ef_sc_hd__decap_12
X_4770_ _0529_ _0530_ _0455_ VGND VGND VPWR VPWR _0531_ sky130_fd_sc_hd__a21o_1
XFILLER_60_286 VPWR VGND VPWR VGND sky130_ef_sc_hd__decap_12
XFILLER_14_681 VGND VGND VPWR VPWR sky130_fd_sc_hd__decap_8
XFILLER_20_128 VPWR VGND VPWR VGND sky130_ef_sc_hd__decap_12
XTAP_TAPCELL_ROW_31_624 VGND VPWR sky130_fd_sc_hd__tapvpwrvgnd_1
X_3721_ _2920_ VGND VGND VPWR VPWR _2921_ sky130_fd_sc_hd__inv_2
XFILLER_13_180 VPWR VGND VPWR VGND sky130_ef_sc_hd__decap_12
X_3652_ _2852_ _2853_ _2854_ VGND VGND VPWR VPWR _2855_ sky130_fd_sc_hd__and3_1
X_6440_ _2010_ _2168_ VGND VGND VPWR VPWR _2329_ sky130_fd_sc_hd__nand2_1
X_3583_ net153 net120 _2695_ VGND VGND VPWR VPWR _2706_ sky130_fd_sc_hd__and3_1
X_6371_ _2093_ _2096_ _2251_ VGND VGND VPWR VPWR _2253_ sky130_fd_sc_hd__and3_1
XTAP_TAPCELL_ROW_11_381 VGND VPWR sky130_fd_sc_hd__tapvpwrvgnd_1
X_5322_ _1106_ _1107_ VGND VGND VPWR VPWR _1108_ sky130_fd_sc_hd__xor2_1
XFILLER_114_222 VGND VGND VPWR VPWR sky130_fd_sc_hd__decap_3
X_5253_ _1012_ _1030_ _1031_ VGND VGND VPWR VPWR _1033_ sky130_fd_sc_hd__nand3_2
X_5184_ net412 net317 net308 net421 VGND VGND VPWR VPWR _0958_ sky130_fd_sc_hd__a22oi_1
X_4204_ net134 _3369_ _3382_ net128 VGND VGND VPWR VPWR _3383_ sky130_fd_sc_hd__o211a_1
XFILLER_56_504 VGND VGND VPWR VPWR sky130_fd_sc_hd__fill_1
XFILLER_3_81 VGND VGND VPWR VPWR sky130_fd_sc_hd__decap_8
X_4135_ _3283_ _3291_ _3314_ _3315_ _3316_ VGND VGND VPWR VPWR _3317_ sky130_fd_sc_hd__a311o_1
XFILLER_113_27 VPWR VGND VPWR VGND sky130_ef_sc_hd__decap_12
XFILLER_56_537 VGND VGND VPWR VPWR sky130_fd_sc_hd__fill_1
XTAP_TAPCELL_ROW_39_724 VGND VPWR sky130_fd_sc_hd__tapvpwrvgnd_1
X_4066_ _3224_ _3230_ _3248_ _3250_ VGND VGND VPWR VPWR _3251_ sky130_fd_sc_hd__a31o_1
XTAP_TAPCELL_ROW_104_1505 VGND VPWR sky130_fd_sc_hd__tapvpwrvgnd_1
XFILLER_24_412 VGND VGND VPWR VPWR sky130_fd_sc_hd__decap_8
XFILLER_36_250 VGND VGND VPWR VPWR sky130_fd_sc_hd__fill_2
XTAP_TAPCELL_ROW_19_481 VGND VPWR sky130_fd_sc_hd__tapvpwrvgnd_1
XFILLER_24_445 VPWR VGND VPWR VGND sky130_ef_sc_hd__decap_12
X_4968_ _0711_ _0725_ VGND VGND VPWR VPWR _0726_ sky130_fd_sc_hd__or2_1
XFILLER_11_106 VGND VGND VPWR VPWR sky130_fd_sc_hd__decap_6
X_4899_ _0646_ _0657_ VGND VGND VPWR VPWR _0658_ sky130_fd_sc_hd__and2b_1
X_3919_ _2933_ _2959_ _3103_ _3110_ VGND VGND VPWR VPWR _alu_i0.Datapath_i.fu_alu_33673_33851.out1\[15\]
+ sky130_fd_sc_hd__a211o_1
X_6707_ net445 net193 _2387_ _2386_ VGND VGND VPWR VPWR _2620_ sky130_fd_sc_hd__a31o_1
X_6638_ _2350_ _2353_ _2543_ VGND VGND VPWR VPWR _2544_ sky130_fd_sc_hd__a21oi_1
XTAP_TAPCELL_ROW_115_1634 VGND VPWR sky130_fd_sc_hd__tapvpwrvgnd_1
XFILLER_3_305 VPWR VGND VPWR VGND sky130_ef_sc_hd__decap_12
X_6569_ _2465_ _2466_ _2296_ _2298_ VGND VGND VPWR VPWR _2470_ sky130_fd_sc_hd__o211ai_1
XFILLER_3_349 VGND VGND VPWR VPWR sky130_fd_sc_hd__decap_3
XFILLER_79_629 VPWR VGND VPWR VGND sky130_ef_sc_hd__decap_12
XFILLER_78_139 VGND VGND VPWR VPWR sky130_fd_sc_hd__fill_1
Xfanout130 _1201_ VGND VGND VPWR VPWR net130 sky130_fd_sc_hd__clkbuf_4
XFILLER_87_673 VPWR VGND VPWR VGND sky130_ef_sc_hd__decap_12
Xfanout141 _1964_ VGND VGND VPWR VPWR net141 sky130_fd_sc_hd__clkbuf_2
Xfanout163 net164 VGND VGND VPWR VPWR net163 sky130_fd_sc_hd__buf_2
Xfanout152 net156 VGND VGND VPWR VPWR net152 sky130_fd_sc_hd__dlymetal6s2s_1
Xfanout174 net175 VGND VGND VPWR VPWR net174 sky130_fd_sc_hd__buf_2
Xfanout196 net197 VGND VGND VPWR VPWR net196 sky130_fd_sc_hd__clkbuf_4
XFILLER_101_461 VPWR VGND VPWR VGND sky130_ef_sc_hd__decap_12
XFILLER_86_172 VPWR VGND VPWR VGND sky130_ef_sc_hd__decap_12
XFILLER_59_375 VPWR VGND VPWR VGND sky130_ef_sc_hd__decap_12
Xfanout185 net188 VGND VGND VPWR VPWR net185 sky130_fd_sc_hd__buf_2
XFILLER_47_54 VGND VGND VPWR VPWR sky130_fd_sc_hd__fill_2
XFILLER_47_98 VPWR VGND VPWR VGND sky130_ef_sc_hd__decap_12
XFILLER_103_93 VPWR VGND VPWR VGND sky130_ef_sc_hd__decap_12
XPHY_EDGE_ROW_69_Right_69 VGND VGND VPWR VPWR sky130_fd_sc_hd__decap_3
XFILLER_42_253 VPWR VGND VPWR VGND sky130_ef_sc_hd__decap_12
XFILLER_70_584 VGND VGND VPWR VPWR sky130_fd_sc_hd__decap_4
XFILLER_8_15 VPWR VGND VPWR VGND sky130_ef_sc_hd__decap_12
XFILLER_30_415 VGND VGND VPWR VPWR sky130_fd_sc_hd__decap_4
XFILLER_30_437 VGND VGND VPWR VPWR sky130_fd_sc_hd__fill_1
XFILLER_42_275 VPWR VGND VPWR VGND sky130_ef_sc_hd__decap_12
XFILLER_11_673 VPWR VGND VPWR VGND sky130_ef_sc_hd__decap_12
XFILLER_10_161 VGND VGND VPWR VPWR sky130_fd_sc_hd__decap_6
XFILLER_109_561 VPWR VGND VPWR VGND sky130_ef_sc_hd__decap_12
XPHY_EDGE_ROW_78_Right_78 VGND VGND VPWR VPWR sky130_fd_sc_hd__decap_3
XFILLER_111_203 VPWR VGND VPWR VGND sky130_ef_sc_hd__decap_12
XTAP_TAPCELL_ROW_90_1328 VGND VPWR sky130_fd_sc_hd__tapvpwrvgnd_1
XFILLER_111_236 VGND VGND VPWR VPWR sky130_fd_sc_hd__fill_1
XFILLER_93_665 VGND VGND VPWR VPWR sky130_fd_sc_hd__decap_6
XFILLER_65_334 VGND VGND VPWR VPWR sky130_fd_sc_hd__fill_2
XFILLER_38_548 VGND VGND VPWR VPWR sky130_fd_sc_hd__fill_1
X_5940_ _1780_ _1781_ _1773_ VGND VGND VPWR VPWR _1783_ sky130_fd_sc_hd__a21o_1
XFILLER_92_197 VGND VGND VPWR VPWR sky130_fd_sc_hd__decap_8
XPHY_EDGE_ROW_87_Right_87 VGND VGND VPWR VPWR sky130_fd_sc_hd__decap_3
XTAP_TAPCELL_ROW_16_440 VGND VPWR sky130_fd_sc_hd__tapvpwrvgnd_1
X_5871_ _1704_ _1705_ _1525_ _1569_ VGND VGND VPWR VPWR _1708_ sky130_fd_sc_hd__o211a_1
X_4822_ net372 net211 net203 net379 VGND VGND VPWR VPWR _0582_ sky130_fd_sc_hd__a22o_1
XFILLER_21_426 VGND VGND VPWR VPWR sky130_fd_sc_hd__fill_2
XFILLER_21_437 VGND VGND VPWR VPWR sky130_fd_sc_hd__decap_3
XFILLER_33_264 VGND VGND VPWR VPWR sky130_fd_sc_hd__fill_2
XFILLER_33_275 VGND VGND VPWR VPWR sky130_fd_sc_hd__decap_4
XTAP_TAPCELL_ROW_44_782 VGND VPWR sky130_fd_sc_hd__tapvpwrvgnd_1
X_4753_ _0506_ _0512_ _0513_ VGND VGND VPWR VPWR _0514_ sky130_fd_sc_hd__nand3_1
XFILLER_21_459 VGND VGND VPWR VPWR sky130_fd_sc_hd__decap_3
X_3704_ net141 _2903_ _2904_ _2900_ VGND VGND VPWR VPWR _2905_ sky130_fd_sc_hd__o31ai_1
X_4684_ _0349_ _0444_ _0445_ VGND VGND VPWR VPWR _0446_ sky130_fd_sc_hd__nand3_1
X_6423_ _2263_ _2264_ _2309_ VGND VGND VPWR VPWR _2310_ sky130_fd_sc_hd__nor3_2
XPHY_EDGE_ROW_96_Right_96 VGND VGND VPWR VPWR sky130_fd_sc_hd__decap_3
X_3635_ net137 _2807_ _2808_ net128 VGND VGND VPWR VPWR _2839_ sky130_fd_sc_hd__o2bb2a_1
XFILLER_108_27 VGND VGND VPWR VPWR sky130_fd_sc_hd__fill_1
X_3566_ _2498_ _2509_ net251 VGND VGND VPWR VPWR _2520_ sky130_fd_sc_hd__mux2_1
X_6354_ _2232_ _2233_ VGND VGND VPWR VPWR _2234_ sky130_fd_sc_hd__xnor2_1
XFILLER_115_553 VGND VGND VPWR VPWR sky130_fd_sc_hd__decap_6
X_5305_ _1087_ _1088_ _0980_ _0984_ VGND VGND VPWR VPWR _1090_ sky130_fd_sc_hd__o211a_1
X_3497_ net408 net400 net392 net378 net356 net289 VGND VGND VPWR VPWR _1768_ sky130_fd_sc_hd__mux4_1
X_6285_ _1947_ _1999_ _2157_ _2158_ VGND VGND VPWR VPWR _2159_ sky130_fd_sc_hd__o211a_1
XFILLER_115_597 VPWR VGND VPWR VGND sky130_ef_sc_hd__decap_12
X_5236_ _0911_ _0914_ VGND VGND VPWR VPWR _1014_ sky130_fd_sc_hd__nand2_1
XTAP_TAPCELL_ROW_110_1575 VGND VPWR sky130_fd_sc_hd__tapvpwrvgnd_1
XFILLER_96_470 VGND VGND VPWR VPWR sky130_fd_sc_hd__decap_6
XFILLER_84_632 VPWR VGND VPWR VGND sky130_ef_sc_hd__decap_12
X_5167_ _0810_ _0822_ _0821_ VGND VGND VPWR VPWR _0940_ sky130_fd_sc_hd__o21ai_1
XFILLER_69_673 VPWR VGND VPWR VGND sky130_ef_sc_hd__decap_12
XPHY_EDGE_ROW_3_Left_120 VGND VGND VPWR VPWR sky130_fd_sc_hd__decap_3
X_5098_ _0760_ _0762_ _0862_ _0864_ VGND VGND VPWR VPWR _0865_ sky130_fd_sc_hd__a211o_1
XFILLER_29_548 VPWR VGND VPWR VGND sky130_ef_sc_hd__decap_12
X_4118_ net140 _3300_ VGND VGND VPWR VPWR _3301_ sky130_fd_sc_hd__or2_1
XFILLER_71_315 VGND VGND VPWR VPWR sky130_fd_sc_hd__decap_8
X_4049_ _3215_ _3228_ _3233_ VGND VGND VPWR VPWR _3235_ sky130_fd_sc_hd__and3_1
XFILLER_17_57 VPWR VGND VPWR VGND sky130_ef_sc_hd__decap_12
XTAP_TAPCELL_ROW_65_1032 VGND VPWR sky130_fd_sc_hd__tapvpwrvgnd_1
XFILLER_24_253 VGND VGND VPWR VPWR sky130_fd_sc_hd__decap_8
XFILLER_24_264 VPWR VGND VPWR VGND sky130_ef_sc_hd__decap_12
XPHY_EDGE_ROW_49_Left_166 VGND VGND VPWR VPWR sky130_fd_sc_hd__decap_3
XFILLER_20_470 VGND VGND VPWR VPWR sky130_fd_sc_hd__decap_6
XFILLER_116_3 VPWR VGND VPWR VGND sky130_ef_sc_hd__decap_12
XFILLER_4_625 VPWR VGND VPWR VGND sky130_ef_sc_hd__decap_12
XFILLER_106_531 VGND VGND VPWR VPWR sky130_fd_sc_hd__fill_1
XFILLER_3_113 VPWR VGND VPWR VGND sky130_ef_sc_hd__decap_12
XTAP_TAPCELL_ROW_76_1161 VGND VPWR sky130_fd_sc_hd__tapvpwrvgnd_1
XFILLER_4_669 VPWR VGND VPWR VGND sky130_ef_sc_hd__decap_12
XFILLER_58_53 VPWR VGND VPWR VGND sky130_ef_sc_hd__decap_12
XFILLER_94_429 VGND VGND VPWR VPWR sky130_fd_sc_hd__fill_2
XFILLER_59_150 VGND VGND VPWR VPWR sky130_fd_sc_hd__decap_8
XPHY_EDGE_ROW_58_Left_175 VGND VGND VPWR VPWR sky130_fd_sc_hd__decap_3
XFILLER_101_291 VGND VGND VPWR VPWR sky130_fd_sc_hd__decap_6
XFILLER_75_665 VGND VGND VPWR VPWR sky130_fd_sc_hd__decap_6
XFILLER_47_345 VGND VGND VPWR VPWR sky130_fd_sc_hd__fill_1
XFILLER_90_613 VPWR VGND VPWR VGND sky130_ef_sc_hd__decap_12
XFILLER_35_518 VGND VGND VPWR VPWR sky130_fd_sc_hd__decap_6
XFILLER_47_378 VPWR VGND VPWR VGND sky130_ef_sc_hd__decap_12
XFILLER_90_657 VPWR VGND VPWR VGND sky130_ef_sc_hd__decap_12
XTAP_TAPCELL_ROW_87_1290 VGND VPWR sky130_fd_sc_hd__tapvpwrvgnd_1
XFILLER_15_264 VGND VGND VPWR VPWR sky130_fd_sc_hd__fill_1
XFILLER_90_73 VGND VGND VPWR VPWR sky130_fd_sc_hd__decap_8
XPHY_EDGE_ROW_67_Left_184 VGND VGND VPWR VPWR sky130_fd_sc_hd__decap_3
XTAP_TAPCELL_ROW_13_410 VGND VPWR sky130_fd_sc_hd__tapvpwrvgnd_1
XTAP_TAPCELL_ROW_41_741 VGND VPWR sky130_fd_sc_hd__tapvpwrvgnd_1
XFILLER_7_485 VPWR VGND VPWR VGND sky130_ef_sc_hd__decap_12
Xmax_cap116 _2101_ VGND VGND VPWR VPWR net116 sky130_fd_sc_hd__clkbuf_2
X_3420_ net193 VGND VGND VPWR VPWR _0928_ sky130_fd_sc_hd__inv_2
XFILLER_112_501 VPWR VGND VPWR VGND sky130_ef_sc_hd__decap_12
XFILLER_3_691 VGND VGND VPWR VPWR sky130_fd_sc_hd__fill_1
XFILLER_31_3 VPWR VGND VPWR VGND sky130_ef_sc_hd__decap_12
XFILLER_112_545 VPWR VGND VPWR VGND sky130_ef_sc_hd__decap_12
XFILLER_97_256 VGND VGND VPWR VPWR sky130_fd_sc_hd__fill_1
XPHY_EDGE_ROW_76_Left_193 VGND VGND VPWR VPWR sky130_fd_sc_hd__decap_3
X_6070_ net382 net314 net305 net429 VGND VGND VPWR VPWR _1924_ sky130_fd_sc_hd__a22o_1
XFILLER_112_589 VPWR VGND VPWR VGND sky130_ef_sc_hd__decap_12
X_5021_ _0686_ _0688_ VGND VGND VPWR VPWR _0781_ sky130_fd_sc_hd__nand2_1
XFILLER_97_289 VPWR VGND VPWR VGND sky130_ef_sc_hd__decap_12
XFILLER_57_109 VGND VGND VPWR VPWR sky130_fd_sc_hd__decap_3
XFILLER_66_643 VGND VGND VPWR VPWR sky130_fd_sc_hd__fill_1
XFILLER_38_345 VGND VGND VPWR VPWR sky130_fd_sc_hd__decap_8
XTAP_TAPCELL_ROW_49_841 VGND VPWR sky130_fd_sc_hd__tapvpwrvgnd_1
XFILLER_81_602 VPWR VGND VPWR VGND sky130_ef_sc_hd__decap_12
XFILLER_26_518 VGND VGND VPWR VPWR sky130_fd_sc_hd__fill_1
XFILLER_38_389 VGND VGND VPWR VPWR sky130_fd_sc_hd__decap_8
XFILLER_53_304 VGND VGND VPWR VPWR sky130_fd_sc_hd__decap_3
XFILLER_80_134 VGND VGND VPWR VPWR sky130_fd_sc_hd__decap_6
XFILLER_65_175 VGND VGND VPWR VPWR sky130_fd_sc_hd__decap_4
XFILLER_0_71 VGND VGND VPWR VPWR sky130_fd_sc_hd__decap_4
XFILLER_53_337 VGND VGND VPWR VPWR sky130_fd_sc_hd__decap_3
X_5923_ net309 net259 net330 net324 VGND VGND VPWR VPWR _1764_ sky130_fd_sc_hd__nand4_1
XFILLER_21_201 VGND VGND VPWR VPWR sky130_fd_sc_hd__fill_2
X_5854_ _1688_ VGND VGND VPWR VPWR _1689_ sky130_fd_sc_hd__inv_2
X_4805_ net240 net227 net433 net386 VGND VGND VPWR VPWR _0565_ sky130_fd_sc_hd__nand4_1
X_5785_ _1480_ _1611_ VGND VGND VPWR VPWR _1613_ sky130_fd_sc_hd__xor2_1
X_4736_ _0494_ _0495_ _0496_ VGND VGND VPWR VPWR _0497_ sky130_fd_sc_hd__and3_1
XFILLER_107_317 VGND VGND VPWR VPWR sky130_fd_sc_hd__decap_3
X_4667_ _0427_ _0428_ VGND VGND VPWR VPWR _0429_ sky130_fd_sc_hd__nor2_1
X_3618_ _2182_ _2226_ net280 VGND VGND VPWR VPWR _2822_ sky130_fd_sc_hd__mux2_1
X_6406_ _2284_ _2289_ VGND VGND VPWR VPWR _2291_ sky130_fd_sc_hd__xnor2_1
X_4598_ _0297_ _0299_ _0298_ VGND VGND VPWR VPWR _0361_ sky130_fd_sc_hd__a21bo_1
X_6337_ _2028_ _2214_ VGND VGND VPWR VPWR _2216_ sky130_fd_sc_hd__nor2_1
XFILLER_1_617 VPWR VGND VPWR VGND sky130_ef_sc_hd__decap_12
XFILLER_103_534 VGND VGND VPWR VPWR sky130_fd_sc_hd__decap_4
X_3549_ net356 net173 VGND VGND VPWR VPWR _2335_ sky130_fd_sc_hd__nand2_2
XFILLER_0_127 VGND VGND VPWR VPWR sky130_fd_sc_hd__fill_2
XFILLER_0_116 VGND VGND VPWR VPWR sky130_fd_sc_hd__fill_1
X_6268_ _2137_ _2138_ _2130_ VGND VGND VPWR VPWR _2141_ sky130_fd_sc_hd__a21o_1
X_5219_ _0992_ _0996_ VGND VGND VPWR VPWR _0997_ sky130_fd_sc_hd__xnor2_1
X_6199_ _1899_ _2063_ _2064_ VGND VGND VPWR VPWR _2065_ sky130_fd_sc_hd__and3_1
XFILLER_56_120 VGND VGND VPWR VPWR sky130_fd_sc_hd__decap_4
XFILLER_29_334 VGND VGND VPWR VPWR sky130_fd_sc_hd__fill_2
XFILLER_84_462 VPWR VGND VPWR VGND sky130_ef_sc_hd__decap_12
XFILLER_72_613 VPWR VGND VPWR VGND sky130_ef_sc_hd__decap_12
XFILLER_72_657 VPWR VGND VPWR VGND sky130_ef_sc_hd__decap_12
XFILLER_25_573 VPWR VGND VPWR VGND sky130_ef_sc_hd__decap_12
XTAP_TAPCELL_ROW_27_579 VGND VPWR sky130_fd_sc_hd__tapvpwrvgnd_1
XFILLER_40_543 VPWR VGND VPWR VGND sky130_ef_sc_hd__decap_12
XFILLER_44_99 VGND VGND VPWR VPWR sky130_fd_sc_hd__decap_8
XFILLER_8_216 VPWR VGND VPWR VGND sky130_ef_sc_hd__decap_12
XFILLER_12_289 VGND VGND VPWR VPWR sky130_fd_sc_hd__fill_2
XFILLER_5_27 VPWR VGND VPWR VGND sky130_ef_sc_hd__decap_12
XFILLER_4_433 VGND VGND VPWR VPWR sky130_fd_sc_hd__fill_2
XFILLER_4_411 VGND VGND VPWR VPWR sky130_fd_sc_hd__fill_1
XFILLER_109_81 VGND VGND VPWR VPWR sky130_fd_sc_hd__decap_3
XFILLER_106_350 VGND VGND VPWR VPWR sky130_fd_sc_hd__fill_1
XFILLER_4_477 VPWR VGND VPWR VGND sky130_ef_sc_hd__decap_12
XFILLER_79_223 VGND VGND VPWR VPWR sky130_fd_sc_hd__fill_1
XFILLER_79_234 VPWR VGND VPWR VGND sky130_ef_sc_hd__decap_12
XFILLER_94_237 VPWR VGND VPWR VGND sky130_ef_sc_hd__decap_12
XTAP_TAPCELL_ROW_46_800 VGND VPWR sky130_fd_sc_hd__tapvpwrvgnd_1
XFILLER_90_421 VPWR VGND VPWR VGND sky130_ef_sc_hd__decap_12
XFILLER_35_326 VGND VGND VPWR VPWR sky130_fd_sc_hd__fill_1
XFILLER_90_454 VGND VGND VPWR VPWR sky130_fd_sc_hd__decap_8
XFILLER_16_540 VGND VGND VPWR VPWR sky130_fd_sc_hd__fill_2
XFILLER_62_167 VPWR VGND VPWR VGND sky130_ef_sc_hd__decap_12
XFILLER_79_3 VPWR VGND VPWR VGND sky130_ef_sc_hd__decap_12
X_5570_ _1376_ _1377_ _1250_ _1253_ VGND VGND VPWR VPWR _1379_ sky130_fd_sc_hd__a211o_1
X_4521_ _0282_ _0285_ VGND VGND VPWR VPWR _0286_ sky130_fd_sc_hd__or2_1
XFILLER_116_125 VPWR VGND VPWR VGND sky130_ef_sc_hd__decap_12
X_4452_ _0215_ _0216_ _0159_ _0173_ VGND VGND VPWR VPWR _0218_ sky130_fd_sc_hd__a2bb2o_1
XFILLER_116_169 VGND VGND VPWR VPWR sky130_fd_sc_hd__decap_4
XFILLER_116_158 VGND VGND VPWR VPWR sky130_fd_sc_hd__decap_8
XPHY_EDGE_ROW_84_Left_201 VGND VGND VPWR VPWR sky130_fd_sc_hd__decap_3
X_4383_ _0149_ _0150_ VGND VGND VPWR VPWR _0151_ sky130_fd_sc_hd__xnor2_1
XFILLER_112_353 VGND VGND VPWR VPWR sky130_fd_sc_hd__decap_8
XFILLER_112_320 VGND VGND VPWR VPWR sky130_fd_sc_hd__fill_1
XFILLER_112_331 VGND VGND VPWR VPWR sky130_fd_sc_hd__decap_4
X_6122_ _1968_ _1979_ _1980_ VGND VGND VPWR VPWR _1981_ sky130_fd_sc_hd__and3_1
XFILLER_105_39 VPWR VGND VPWR VGND sky130_ef_sc_hd__decap_12
XFILLER_98_587 VGND VGND VPWR VPWR sky130_fd_sc_hd__fill_1
XFILLER_85_215 VGND VGND VPWR VPWR sky130_fd_sc_hd__decap_8
X_6053_ _1903_ _1904_ VGND VGND VPWR VPWR _1905_ sky130_fd_sc_hd__and2b_1
X_5004_ _0668_ _0670_ _0759_ _0761_ VGND VGND VPWR VPWR _0762_ sky130_fd_sc_hd__a211o_1
XFILLER_38_131 VGND VGND VPWR VPWR sky130_fd_sc_hd__decap_8
XFILLER_39_665 VGND VGND VPWR VPWR sky130_fd_sc_hd__decap_6
XFILLER_93_281 VGND VGND VPWR VPWR sky130_fd_sc_hd__decap_8
XFILLER_81_432 VPWR VGND VPWR VGND sky130_ef_sc_hd__decap_12
XPHY_EDGE_ROW_93_Left_210 VGND VGND VPWR VPWR sky130_fd_sc_hd__decap_3
XFILLER_54_657 VPWR VGND VPWR VGND sky130_ef_sc_hd__decap_12
XFILLER_81_476 VGND VGND VPWR VPWR sky130_fd_sc_hd__fill_2
X_5906_ net388 net375 net299 net294 VGND VGND VPWR VPWR _1745_ sky130_fd_sc_hd__and4_1
XFILLER_53_167 VGND VGND VPWR VPWR sky130_fd_sc_hd__fill_1
X_6886_ net181 _alu_i0.Datapath_i.fu_alu_33673_33851.out1\[12\] VGND VGND VPWR VPWR
+ _alu_i0.Datapath_i.reg_0.reg_out1\[12\] sky130_fd_sc_hd__dfxtp_1
XTAP_TAPCELL_ROW_24_538 VGND VPWR sky130_fd_sc_hd__tapvpwrvgnd_1
XFILLER_22_587 VGND VGND VPWR VPWR sky130_fd_sc_hd__fill_1
X_5837_ _1668_ _1669_ VGND VGND VPWR VPWR _1671_ sky130_fd_sc_hd__or2_1
X_5768_ _1592_ _1594_ VGND VGND VPWR VPWR _1595_ sky130_fd_sc_hd__xnor2_1
X_4719_ net424 net338 VGND VGND VPWR VPWR _0480_ sky130_fd_sc_hd__and2_1
XFILLER_5_219 VGND VGND VPWR VPWR sky130_fd_sc_hd__decap_4
XFILLER_108_637 VGND VGND VPWR VPWR sky130_fd_sc_hd__decap_6
XFILLER_107_125 VPWR VGND VPWR VGND sky130_ef_sc_hd__decap_12
X_5699_ _1515_ _1516_ _1394_ VGND VGND VPWR VPWR _1520_ sky130_fd_sc_hd__a21oi_1
XFILLER_107_169 VPWR VGND VPWR VGND sky130_ef_sc_hd__decap_12
XTAP_TAPCELL_ROW_73_1131 VGND VPWR sky130_fd_sc_hd__tapvpwrvgnd_1
XFILLER_1_414 VGND VGND VPWR VPWR sky130_fd_sc_hd__decap_8
XFILLER_1_469 VGND VGND VPWR VPWR sky130_fd_sc_hd__decap_4
XFILLER_39_55 VGND VGND VPWR VPWR sky130_fd_sc_hd__fill_1
XFILLER_72_421 VPWR VGND VPWR VGND sky130_ef_sc_hd__decap_12
XFILLER_57_473 VGND VGND VPWR VPWR sky130_fd_sc_hd__decap_4
XTAP_TAPCELL_ROW_4_296 VGND VPWR sky130_fd_sc_hd__tapvpwrvgnd_1
XFILLER_44_145 VGND VGND VPWR VPWR sky130_fd_sc_hd__decap_6
XPHY_EDGE_ROW_105_Right_105 VGND VGND VPWR VPWR sky130_fd_sc_hd__decap_3
XTAP_TAPCELL_ROW_84_1260 VGND VPWR sky130_fd_sc_hd__tapvpwrvgnd_1
XFILLER_32_329 VGND VGND VPWR VPWR sky130_fd_sc_hd__fill_2
XFILLER_111_93 VPWR VGND VPWR VGND sky130_ef_sc_hd__decap_12
XFILLER_9_536 VGND VGND VPWR VPWR sky130_fd_sc_hd__fill_2
XFILLER_40_373 VGND VGND VPWR VPWR sky130_fd_sc_hd__fill_1
XFILLER_95_535 VGND VGND VPWR VPWR sky130_fd_sc_hd__decap_6
XFILLER_82_207 VPWR VGND VPWR VGND sky130_ef_sc_hd__decap_12
XFILLER_36_657 VPWR VGND VPWR VGND sky130_ef_sc_hd__decap_12
XFILLER_90_251 VGND VGND VPWR VPWR sky130_fd_sc_hd__fill_1
XFILLER_63_498 VGND VGND VPWR VPWR sky130_fd_sc_hd__decap_6
XFILLER_23_329 VGND VGND VPWR VPWR sky130_fd_sc_hd__decap_6
XFILLER_35_189 VPWR VGND VPWR VGND sky130_ef_sc_hd__decap_12
X_6740_ _2653_ _2654_ _2444_ _2448_ VGND VGND VPWR VPWR _2656_ sky130_fd_sc_hd__a211oi_1
X_3952_ net166 net304 VGND VGND VPWR VPWR _3142_ sky130_fd_sc_hd__nand2_1
X_3883_ _3048_ _3054_ VGND VGND VPWR VPWR _3076_ sky130_fd_sc_hd__nor2_1
XTAP_TAPCELL_ROW_21_508 VGND VPWR sky130_fd_sc_hd__tapvpwrvgnd_1
X_6671_ net171 net320 _2578_ VGND VGND VPWR VPWR _2580_ sky130_fd_sc_hd__a21oi_1
X_5622_ _1313_ _1434_ _1435_ VGND VGND VPWR VPWR _1436_ sky130_fd_sc_hd__and3_1
XTAP_TAPCELL_ROW_98_1429 VGND VPWR sky130_fd_sc_hd__tapvpwrvgnd_1
X_5553_ net168 net212 _1357_ _1358_ VGND VGND VPWR VPWR _1360_ sky130_fd_sc_hd__nand4_2
X_4504_ _0215_ _0267_ _0268_ VGND VGND VPWR VPWR _0269_ sky130_fd_sc_hd__nand3_1
X_5484_ _1280_ _1282_ _1283_ VGND VGND VPWR VPWR _1285_ sky130_fd_sc_hd__and3b_1
XFILLER_105_629 VPWR VGND VPWR VGND sky130_ef_sc_hd__decap_12
X_4435_ net243 net225 net406 net398 VGND VGND VPWR VPWR _0201_ sky130_fd_sc_hd__nand4_1
XFILLER_116_27 VGND VGND VPWR VPWR sky130_fd_sc_hd__fill_1
X_4366_ _0130_ _0131_ _0132_ VGND VGND VPWR VPWR _0134_ sky130_fd_sc_hd__a21o_1
XFILLER_113_673 VPWR VGND VPWR VGND sky130_ef_sc_hd__decap_12
X_6105_ _1960_ _1961_ VGND VGND VPWR VPWR _1962_ sky130_fd_sc_hd__nand2b_1
X_4297_ _0054_ _0067_ VGND VGND VPWR VPWR _0068_ sky130_fd_sc_hd__or2_1
XFILLER_86_579 VGND VGND VPWR VPWR sky130_fd_sc_hd__decap_8
X_6036_ net388 net275 _1884_ _1885_ VGND VGND VPWR VPWR _1886_ sky130_fd_sc_hd__nand4_1
XTAP_TAPCELL_ROW_57_939 VGND VPWR sky130_fd_sc_hd__tapvpwrvgnd_1
XFILLER_54_421 VGND VGND VPWR VPWR sky130_fd_sc_hd__decap_6
XTAP_TAPCELL_ROW_107_1536 VGND VPWR sky130_fd_sc_hd__tapvpwrvgnd_1
XFILLER_54_443 VGND VGND VPWR VPWR sky130_fd_sc_hd__decap_3
XTAP_TAPCELL_ROW_1_266 VGND VPWR sky130_fd_sc_hd__tapvpwrvgnd_1
XFILLER_14_307 VGND VGND VPWR VPWR sky130_fd_sc_hd__fill_1
XFILLER_25_57 VPWR VGND VPWR VGND sky130_ef_sc_hd__decap_12
XTAP_TAPCELL_ROW_37_696 VGND VPWR sky130_fd_sc_hd__tapvpwrvgnd_1
X_6869_ _alu_i0.Controller_i._present_state\[1\] _alu_i0.Controller_i._present_state\[2\]
+ net74 net75 VGND VGND VPWR VPWR _2796_ sky130_fd_sc_hd__and4bb_1
XFILLER_10_557 VPWR VGND VPWR VGND sky130_ef_sc_hd__decap_12
XTAP_TAPCELL_ROW_9_355 VGND VPWR sky130_fd_sc_hd__tapvpwrvgnd_1
XFILLER_9_3 VPWR VGND VPWR VGND sky130_ef_sc_hd__decap_12
XFILLER_1_222 VGND VGND VPWR VPWR sky130_fd_sc_hd__fill_2
XFILLER_66_20 VGND VGND VPWR VPWR sky130_fd_sc_hd__decap_8
XFILLER_49_237 VGND VGND VPWR VPWR sky130_fd_sc_hd__decap_4
XFILLER_92_549 VGND VGND VPWR VPWR sky130_fd_sc_hd__fill_1
XFILLER_66_97 VGND VGND VPWR VPWR sky130_fd_sc_hd__decap_3
XFILLER_64_229 VGND VGND VPWR VPWR sky130_fd_sc_hd__decap_8
XFILLER_57_281 VGND VGND VPWR VPWR sky130_fd_sc_hd__decap_4
XFILLER_17_101 VGND VGND VPWR VPWR sky130_fd_sc_hd__decap_8
XFILLER_18_613 VPWR VGND VPWR VGND sky130_ef_sc_hd__decap_12
XFILLER_18_657 VPWR VGND VPWR VGND sky130_ef_sc_hd__decap_12
XFILLER_72_251 VGND VGND VPWR VPWR sky130_fd_sc_hd__fill_1
XFILLER_32_104 VGND VGND VPWR VPWR sky130_fd_sc_hd__decap_8
XFILLER_32_137 VGND VGND VPWR VPWR sky130_fd_sc_hd__decap_3
XFILLER_82_85 VGND VGND VPWR VPWR sky130_fd_sc_hd__decap_3
XFILLER_13_362 VGND VGND VPWR VPWR sky130_fd_sc_hd__decap_3
XFILLER_13_384 VGND VGND VPWR VPWR sky130_fd_sc_hd__decap_3
XFILLER_41_671 VGND VGND VPWR VPWR sky130_fd_sc_hd__fill_1
Xoutput107 net107 VGND VGND VPWR VPWR return_port[8] sky130_fd_sc_hd__clkbuf_4
XFILLER_5_561 VPWR VGND VPWR VGND sky130_ef_sc_hd__decap_12
X_4220_ _3393_ _3397_ net124 VGND VGND VPWR VPWR _3398_ sky130_fd_sc_hd__o21ai_1
XFILLER_110_643 VGND VGND VPWR VPWR sky130_fd_sc_hd__fill_1
XFILLER_68_546 VGND VGND VPWR VPWR sky130_fd_sc_hd__fill_1
X_4151_ net435 net255 VGND VGND VPWR VPWR _3332_ sky130_fd_sc_hd__or2_1
X_4082_ net144 _3265_ net138 VGND VGND VPWR VPWR _3266_ sky130_fd_sc_hd__a21o_1
XFILLER_36_421 VGND VGND VPWR VPWR sky130_fd_sc_hd__fill_1
XFILLER_102_29 VPWR VGND VPWR VGND sky130_ef_sc_hd__decap_12
XFILLER_23_104 VGND VGND VPWR VPWR sky130_fd_sc_hd__decap_8
XFILLER_91_593 VPWR VGND VPWR VGND sky130_ef_sc_hd__decap_12
X_4984_ _0740_ _0741_ VGND VGND VPWR VPWR _0742_ sky130_fd_sc_hd__nor2_1
XFILLER_63_295 VPWR VGND VPWR VGND sky130_ef_sc_hd__decap_12
XFILLER_23_137 VGND VGND VPWR VPWR sky130_fd_sc_hd__decap_6
X_3935_ _3075_ _3097_ _3125_ VGND VGND VPWR VPWR _3126_ sky130_fd_sc_hd__a21boi_1
X_6723_ _2634_ _2635_ _2462_ _2465_ VGND VGND VPWR VPWR _2637_ sky130_fd_sc_hd__a211o_1
XTAP_TAPCELL_ROW_34_655 VGND VPWR sky130_fd_sc_hd__tapvpwrvgnd_1
XTAP_TAPCELL_ROW_102_1477 VGND VPWR sky130_fd_sc_hd__tapvpwrvgnd_1
XTAP_TAPCELL_ROW_62_997 VGND VPWR sky130_fd_sc_hd__tapvpwrvgnd_1
X_6654_ _2559_ _2560_ VGND VGND VPWR VPWR _2561_ sky130_fd_sc_hd__xor2_1
X_3866_ net143 _3049_ _3059_ net140 _3055_ VGND VGND VPWR VPWR _3060_ sky130_fd_sc_hd__o221a_1
XPHY_EDGE_ROW_12_Left_129 VGND VGND VPWR VPWR sky130_fd_sc_hd__decap_3
X_5605_ net368 net320 _1415_ _1416_ VGND VGND VPWR VPWR _1417_ sky130_fd_sc_hd__a22o_1
X_3797_ net136 _2982_ net130 VGND VGND VPWR VPWR _2994_ sky130_fd_sc_hd__o21ai_1
XFILLER_11_15 VPWR VGND VPWR VGND sky130_ef_sc_hd__decap_12
X_6585_ _2278_ _2280_ _2485_ _2486_ VGND VGND VPWR VPWR _2487_ sky130_fd_sc_hd__a211oi_1
X_5536_ _1339_ _1340_ VGND VGND VPWR VPWR _1341_ sky130_fd_sc_hd__xor2_1
X_5467_ _1264_ _1265_ VGND VGND VPWR VPWR _1267_ sky130_fd_sc_hd__and2b_1
X_4418_ _0148_ _0150_ _0147_ VGND VGND VPWR VPWR _0185_ sky130_fd_sc_hd__a21o_1
XFILLER_99_671 VGND VGND VPWR VPWR sky130_fd_sc_hd__fill_1
XFILLER_59_502 VGND VGND VPWR VPWR sky130_fd_sc_hd__fill_2
X_5398_ _1188_ _1189_ _1152_ VGND VGND VPWR VPWR _1192_ sky130_fd_sc_hd__a21oi_1
Xfanout312 net313 VGND VGND VPWR VPWR net312 sky130_fd_sc_hd__buf_2
XTAP_TAPCELL_ROW_6_325 VGND VPWR sky130_fd_sc_hd__tapvpwrvgnd_1
Xfanout301 net304 VGND VGND VPWR VPWR net301 sky130_fd_sc_hd__clkbuf_4
Xfanout323 net324 VGND VGND VPWR VPWR net323 sky130_fd_sc_hd__buf_2
Xfanout334 net335 VGND VGND VPWR VPWR net334 sky130_fd_sc_hd__clkbuf_4
Xfanout345 net34 VGND VGND VPWR VPWR net345 sky130_fd_sc_hd__clkbuf_4
X_4349_ _0116_ _0117_ VGND VGND VPWR VPWR _0118_ sky130_fd_sc_hd__xnor2_1
XFILLER_86_321 VGND VGND VPWR VPWR sky130_fd_sc_hd__fill_2
Xfanout356 net357 VGND VGND VPWR VPWR net356 sky130_fd_sc_hd__clkbuf_4
XFILLER_101_665 VGND VGND VPWR VPWR sky130_fd_sc_hd__decap_6
Xfanout378 net381 VGND VGND VPWR VPWR net378 sky130_fd_sc_hd__clkbuf_4
XFILLER_59_568 VGND VGND VPWR VPWR sky130_fd_sc_hd__decap_4
Xfanout367 net369 VGND VGND VPWR VPWR net367 sky130_fd_sc_hd__clkbuf_4
Xfanout389 net390 VGND VGND VPWR VPWR net389 sky130_fd_sc_hd__buf_2
XPHY_EDGE_ROW_21_Left_138 VGND VGND VPWR VPWR sky130_fd_sc_hd__decap_3
XFILLER_100_153 VGND VGND VPWR VPWR sky130_fd_sc_hd__decap_4
XFILLER_86_376 VPWR VGND VPWR VGND sky130_ef_sc_hd__decap_12
X_6019_ net413 net266 VGND VGND VPWR VPWR _1868_ sky130_fd_sc_hd__nand2_1
XFILLER_100_197 VPWR VGND VPWR VGND sky130_ef_sc_hd__decap_12
XFILLER_39_281 VGND VGND VPWR VPWR sky130_fd_sc_hd__decap_6
XTAP_TAPCELL_ROW_68_1063 VGND VPWR sky130_fd_sc_hd__tapvpwrvgnd_1
XFILLER_14_104 VPWR VGND VPWR VGND sky130_ef_sc_hd__decap_12
XFILLER_52_33 VGND VGND VPWR VPWR sky130_fd_sc_hd__fill_1
XFILLER_23_671 VGND VGND VPWR VPWR sky130_fd_sc_hd__fill_1
XPHY_EDGE_ROW_30_Left_147 VGND VGND VPWR VPWR sky130_fd_sc_hd__decap_3
XFILLER_52_55 VGND VGND VPWR VPWR sky130_fd_sc_hd__fill_2
XFILLER_10_365 VPWR VGND VPWR VGND sky130_ef_sc_hd__decap_12
XFILLER_6_369 VGND VGND VPWR VPWR sky130_fd_sc_hd__fill_1
XFILLER_108_264 VGND VGND VPWR VPWR sky130_fd_sc_hd__decap_8
XFILLER_2_531 VGND VGND VPWR VPWR sky130_fd_sc_hd__fill_1
XFILLER_111_429 VPWR VGND VPWR VGND sky130_ef_sc_hd__decap_12
XFILLER_77_310 VGND VGND VPWR VPWR sky130_fd_sc_hd__fill_1
XFILLER_65_505 VPWR VGND VPWR VGND sky130_ef_sc_hd__decap_12
XFILLER_77_376 VGND VGND VPWR VPWR sky130_fd_sc_hd__decap_8
X_3720_ _2918_ _2919_ VGND VGND VPWR VPWR _2920_ sky130_fd_sc_hd__nor2_1
XFILLER_60_298 VGND VGND VPWR VPWR sky130_fd_sc_hd__decap_4
XTAP_TAPCELL_ROW_31_625 VGND VPWR sky130_fd_sc_hd__tapvpwrvgnd_1
XFILLER_13_192 VPWR VGND VPWR VGND sky130_ef_sc_hd__decap_12
X_3651_ net144 _2842_ VGND VGND VPWR VPWR _2854_ sky130_fd_sc_hd__nand2_1
X_3582_ _2684_ VGND VGND VPWR VPWR _2695_ sky130_fd_sc_hd__inv_2
X_6370_ _2093_ _2096_ _2251_ VGND VGND VPWR VPWR _2252_ sky130_fd_sc_hd__a21oi_2
XTAP_TAPCELL_ROW_11_382 VGND VPWR sky130_fd_sc_hd__tapvpwrvgnd_1
X_5321_ net246 net467 VGND VGND VPWR VPWR _1107_ sky130_fd_sc_hd__nand2_1
X_5252_ _1030_ _1031_ _1012_ VGND VGND VPWR VPWR _1032_ sky130_fd_sc_hd__a21o_1
X_5183_ net420 net411 net317 net308 VGND VGND VPWR VPWR _0957_ sky130_fd_sc_hd__and4_1
X_4203_ net142 _3370_ _3381_ VGND VGND VPWR VPWR _3382_ sky130_fd_sc_hd__o21ai_1
XFILLER_68_365 VGND VGND VPWR VPWR sky130_fd_sc_hd__decap_8
X_4134_ _3283_ _3314_ net125 VGND VGND VPWR VPWR _3316_ sky130_fd_sc_hd__o21ai_1
XFILLER_83_324 VPWR VGND VPWR VGND sky130_ef_sc_hd__decap_12
XTAP_TAPCELL_ROW_39_714 VGND VPWR sky130_fd_sc_hd__tapvpwrvgnd_1
XTAP_TAPCELL_ROW_39_725 VGND VPWR sky130_fd_sc_hd__tapvpwrvgnd_1
XFILLER_113_39 VPWR VGND VPWR VGND sky130_ef_sc_hd__decap_12
X_4065_ net126 _3249_ VGND VGND VPWR VPWR _3250_ sky130_fd_sc_hd__nand2_1
XFILLER_24_402 VGND VGND VPWR VPWR sky130_fd_sc_hd__decap_3
XFILLER_36_240 VGND VGND VPWR VPWR sky130_fd_sc_hd__decap_3
XTAP_TAPCELL_ROW_19_482 VGND VPWR sky130_fd_sc_hd__tapvpwrvgnd_1
XFILLER_24_457 VGND VGND VPWR VPWR sky130_fd_sc_hd__fill_2
X_4967_ _0715_ _0724_ VGND VGND VPWR VPWR _0725_ sky130_fd_sc_hd__xnor2_1
X_4898_ _0647_ _0656_ VGND VGND VPWR VPWR _0657_ sky130_fd_sc_hd__xnor2_1
X_3918_ net118 _3108_ _3109_ VGND VGND VPWR VPWR _3110_ sky130_fd_sc_hd__a21o_1
X_6706_ _2452_ _2455_ _2453_ VGND VGND VPWR VPWR _2618_ sky130_fd_sc_hd__o21ba_1
X_3849_ net154 _3042_ _3043_ VGND VGND VPWR VPWR _3044_ sky130_fd_sc_hd__a21bo_1
X_6637_ _2540_ _2541_ VGND VGND VPWR VPWR _2543_ sky130_fd_sc_hd__or2_1
X_6568_ _2468_ VGND VGND VPWR VPWR _2469_ sky130_fd_sc_hd__inv_2
XTAP_TAPCELL_ROW_115_1635 VGND VPWR sky130_fd_sc_hd__tapvpwrvgnd_1
XFILLER_98_29 VPWR VGND VPWR VGND sky130_ef_sc_hd__decap_12
X_5519_ _1140_ _1142_ _1322_ _1323_ VGND VGND VPWR VPWR _1324_ sky130_fd_sc_hd__o211a_1
XFILLER_3_317 VPWR VGND VPWR VGND sky130_ef_sc_hd__decap_12
X_6499_ _2391_ _2392_ VGND VGND VPWR VPWR _2393_ sky130_fd_sc_hd__nor2_1
Xfanout120 net122 VGND VGND VPWR VPWR net120 sky130_fd_sc_hd__clkbuf_4
Xfanout131 net133 VGND VGND VPWR VPWR net131 sky130_fd_sc_hd__clkbuf_4
XFILLER_87_641 VPWR VGND VPWR VGND sky130_ef_sc_hd__decap_12
Xfanout153 net156 VGND VGND VPWR VPWR net153 sky130_fd_sc_hd__buf_2
XFILLER_47_505 VGND VGND VPWR VPWR sky130_fd_sc_hd__decap_6
Xfanout142 _1146_ VGND VGND VPWR VPWR net142 sky130_fd_sc_hd__clkbuf_4
Xfanout164 net165 VGND VGND VPWR VPWR net164 sky130_fd_sc_hd__buf_2
Xfanout197 net63 VGND VGND VPWR VPWR net197 sky130_fd_sc_hd__clkbuf_4
XFILLER_101_473 VGND VGND VPWR VPWR sky130_fd_sc_hd__decap_8
XFILLER_87_685 VGND VGND VPWR VPWR sky130_fd_sc_hd__decap_6
XFILLER_59_387 VGND VGND VPWR VPWR sky130_fd_sc_hd__decap_4
Xfanout175 net178 VGND VGND VPWR VPWR net175 sky130_fd_sc_hd__clkbuf_4
Xfanout186 net188 VGND VGND VPWR VPWR net186 sky130_fd_sc_hd__buf_2
XFILLER_86_184 VPWR VGND VPWR VGND sky130_ef_sc_hd__decap_12
XFILLER_63_32 VGND VGND VPWR VPWR sky130_fd_sc_hd__decap_8
XFILLER_70_552 VGND VGND VPWR VPWR sky130_fd_sc_hd__decap_4
XFILLER_42_232 VPWR VGND VPWR VGND sky130_ef_sc_hd__decap_12
XFILLER_70_596 VPWR VGND VPWR VGND sky130_ef_sc_hd__decap_12
XFILLER_42_265 VGND VGND VPWR VPWR sky130_fd_sc_hd__decap_4
XFILLER_42_287 VGND VGND VPWR VPWR sky130_fd_sc_hd__decap_4
XFILLER_11_641 VPWR VGND VPWR VGND sky130_ef_sc_hd__decap_12
XFILLER_8_27 VGND VGND VPWR VPWR sky130_fd_sc_hd__fill_1
XFILLER_42_298 VGND VGND VPWR VPWR sky130_fd_sc_hd__decap_8
XFILLER_11_685 VGND VGND VPWR VPWR sky130_fd_sc_hd__decap_6
XFILLER_109_551 VGND VGND VPWR VPWR sky130_fd_sc_hd__decap_8
XFILLER_10_195 VGND VGND VPWR VPWR sky130_fd_sc_hd__fill_1
XFILLER_109_573 VPWR VGND VPWR VGND sky130_ef_sc_hd__decap_12
XFILLER_88_40 VGND VGND VPWR VPWR sky130_fd_sc_hd__decap_8
XFILLER_97_405 VPWR VGND VPWR VGND sky130_ef_sc_hd__decap_12
XTAP_TAPCELL_ROW_90_1329 VGND VPWR sky130_fd_sc_hd__tapvpwrvgnd_1
XFILLER_111_215 VGND VGND VPWR VPWR sky130_fd_sc_hd__decap_3
XFILLER_97_449 VPWR VGND VPWR VGND sky130_ef_sc_hd__decap_12
XFILLER_38_538 VGND VGND VPWR VPWR sky130_fd_sc_hd__decap_3
XFILLER_53_519 VPWR VGND VPWR VGND sky130_ef_sc_hd__decap_12
XFILLER_18_251 VGND VGND VPWR VPWR sky130_fd_sc_hd__fill_1
X_5870_ _1706_ VGND VGND VPWR VPWR _1707_ sky130_fd_sc_hd__inv_2
X_4821_ net401 net195 _0477_ _0476_ VGND VGND VPWR VPWR _0581_ sky130_fd_sc_hd__a31o_1
XFILLER_61_541 VGND VGND VPWR VPWR sky130_fd_sc_hd__decap_6
XTAP_TAPCELL_ROW_16_441 VGND VPWR sky130_fd_sc_hd__tapvpwrvgnd_1
XTAP_TAPCELL_ROW_44_783 VGND VPWR sky130_fd_sc_hd__tapvpwrvgnd_1
X_4752_ _0510_ _0511_ _0507_ VGND VGND VPWR VPWR _0513_ sky130_fd_sc_hd__a21o_1
X_4683_ _0436_ _0442_ _0443_ VGND VGND VPWR VPWR _0445_ sky130_fd_sc_hd__nand3_1
X_3703_ _2896_ _2901_ _2902_ VGND VGND VPWR VPWR _2904_ sky130_fd_sc_hd__and3_1
X_3634_ net250 net231 _2837_ VGND VGND VPWR VPWR _2838_ sky130_fd_sc_hd__or3b_1
X_6422_ _2307_ _2308_ VGND VGND VPWR VPWR _2309_ sky130_fd_sc_hd__nand2_1
X_3565_ _1375_ _1419_ net282 VGND VGND VPWR VPWR _2509_ sky130_fd_sc_hd__mux2_1
X_6353_ net166 net336 VGND VGND VPWR VPWR _2233_ sky130_fd_sc_hd__nand2_1
X_3496_ net355 net377 VGND VGND VPWR VPWR _1757_ sky130_fd_sc_hd__nand2_1
X_5304_ _0980_ _0984_ _1087_ _1088_ VGND VGND VPWR VPWR _1089_ sky130_fd_sc_hd__a211oi_2
XFILLER_0_309 VPWR VGND VPWR VGND sky130_ef_sc_hd__decap_12
X_6284_ _2110_ _2111_ _2155_ _2156_ VGND VGND VPWR VPWR _2158_ sky130_fd_sc_hd__a22o_1
X_5235_ _0945_ _0954_ _0953_ VGND VGND VPWR VPWR _1013_ sky130_fd_sc_hd__a21o_1
XFILLER_69_641 VPWR VGND VPWR VGND sky130_ef_sc_hd__decap_12
XTAP_TAPCELL_ROW_110_1576 VGND VPWR sky130_fd_sc_hd__tapvpwrvgnd_1
XFILLER_69_685 VGND VGND VPWR VPWR sky130_fd_sc_hd__decap_6
X_5166_ _0936_ _0937_ VGND VGND VPWR VPWR _0938_ sky130_fd_sc_hd__nor2_1
X_5097_ _0860_ _0861_ _0755_ _0758_ VGND VGND VPWR VPWR _0864_ sky130_fd_sc_hd__o211a_1
X_4117_ _3285_ _3299_ VGND VGND VPWR VPWR _3300_ sky130_fd_sc_hd__nor2_1
X_4048_ _3215_ _3233_ _3228_ VGND VGND VPWR VPWR _3234_ sky130_fd_sc_hd__a21o_1
XFILLER_17_69 VPWR VGND VPWR VGND sky130_ef_sc_hd__decap_12
XTAP_TAPCELL_ROW_65_1033 VGND VPWR sky130_fd_sc_hd__tapvpwrvgnd_1
XFILLER_52_585 VGND VGND VPWR VPWR sky130_fd_sc_hd__decap_3
XFILLER_24_276 VGND VGND VPWR VPWR sky130_fd_sc_hd__decap_6
X_5999_ _1799_ _1800_ _1843_ _1845_ VGND VGND VPWR VPWR _1847_ sky130_fd_sc_hd__a22o_1
XFILLER_33_57 VPWR VGND VPWR VGND sky130_ef_sc_hd__decap_12
XPHY_EDGE_ROW_104_Left_221 VGND VGND VPWR VPWR sky130_fd_sc_hd__decap_3
XFILLER_109_3 VPWR VGND VPWR VGND sky130_ef_sc_hd__decap_12
XFILLER_4_637 VGND VGND VPWR VPWR sky130_fd_sc_hd__decap_6
XFILLER_3_125 VGND VGND VPWR VPWR sky130_fd_sc_hd__fill_2
XFILLER_79_405 VPWR VGND VPWR VGND sky130_ef_sc_hd__decap_12
XTAP_TAPCELL_ROW_76_1162 VGND VPWR sky130_fd_sc_hd__tapvpwrvgnd_1
XFILLER_3_169 VGND VGND VPWR VPWR sky130_fd_sc_hd__decap_4
XFILLER_106_587 VGND VGND VPWR VPWR sky130_fd_sc_hd__fill_1
XFILLER_79_449 VPWR VGND VPWR VGND sky130_ef_sc_hd__decap_12
XFILLER_58_65 VPWR VGND VPWR VGND sky130_ef_sc_hd__decap_12
XPHY_EDGE_ROW_113_Left_230 VGND VGND VPWR VPWR sky130_fd_sc_hd__decap_3
XFILLER_101_281 VGND VGND VPWR VPWR sky130_fd_sc_hd__decap_6
XFILLER_90_625 VPWR VGND VPWR VGND sky130_ef_sc_hd__decap_12
XFILLER_90_669 VPWR VGND VPWR VGND sky130_ef_sc_hd__decap_12
XTAP_TAPCELL_ROW_87_1291 VGND VPWR sky130_fd_sc_hd__tapvpwrvgnd_1
XFILLER_55_390 VGND VGND VPWR VPWR sky130_fd_sc_hd__fill_2
XFILLER_70_360 VGND VGND VPWR VPWR sky130_fd_sc_hd__decap_4
XFILLER_43_574 VPWR VGND VPWR VGND sky130_ef_sc_hd__decap_12
XFILLER_90_52 VGND VGND VPWR VPWR sky130_fd_sc_hd__fill_1
XFILLER_90_41 VGND VGND VPWR VPWR sky130_fd_sc_hd__decap_4
XTAP_TAPCELL_ROW_13_411 VGND VPWR sky130_fd_sc_hd__tapvpwrvgnd_1
XTAP_TAPCELL_ROW_41_742 VGND VPWR sky130_fd_sc_hd__tapvpwrvgnd_1
XFILLER_90_85 VGND VGND VPWR VPWR sky130_fd_sc_hd__fill_2
XFILLER_99_72 VPWR VGND VPWR VGND sky130_ef_sc_hd__decap_12
Xmax_cap139 _1059_ VGND VGND VPWR VPWR net139 sky130_fd_sc_hd__clkbuf_2
XFILLER_7_497 VGND VGND VPWR VPWR sky130_fd_sc_hd__decap_6
XFILLER_112_513 VPWR VGND VPWR VGND sky130_ef_sc_hd__decap_12
XFILLER_112_557 VPWR VGND VPWR VGND sky130_ef_sc_hd__decap_12
X_5020_ _0777_ _0778_ _0681_ VGND VGND VPWR VPWR _0780_ sky130_fd_sc_hd__o21a_1
XFILLER_78_471 VGND VGND VPWR VPWR sky130_fd_sc_hd__decap_4
XFILLER_24_3 VPWR VGND VPWR VGND sky130_ef_sc_hd__decap_12
XFILLER_38_313 VGND VGND VPWR VPWR sky130_fd_sc_hd__fill_1
XFILLER_65_110 VGND VGND VPWR VPWR sky130_fd_sc_hd__fill_2
XTAP_TAPCELL_ROW_49_842 VGND VPWR sky130_fd_sc_hd__tapvpwrvgnd_1
XFILLER_81_614 VGND VGND VPWR VPWR sky130_fd_sc_hd__fill_2
XFILLER_38_357 VGND VGND VPWR VPWR sky130_fd_sc_hd__decap_6
XFILLER_19_582 VPWR VGND VPWR VGND sky130_ef_sc_hd__decap_12
XFILLER_0_83 VGND VGND VPWR VPWR sky130_fd_sc_hd__fill_1
X_5922_ _1761_ _1762_ VGND VGND VPWR VPWR _1763_ sky130_fd_sc_hd__xnor2_1
XFILLER_110_29 VPWR VGND VPWR VGND sky130_ef_sc_hd__decap_12
X_5853_ _1675_ _1686_ _1687_ VGND VGND VPWR VPWR _1688_ sky130_fd_sc_hd__and3_1
X_4804_ net251 net311 VGND VGND VPWR VPWR _0564_ sky130_fd_sc_hd__and2_1
XFILLER_61_393 VPWR VGND VPWR VGND sky130_ef_sc_hd__decap_12
X_5784_ _1480_ _1611_ VGND VGND VPWR VPWR _1612_ sky130_fd_sc_hd__or2_1
X_4735_ _0421_ _0423_ _0422_ VGND VGND VPWR VPWR _0496_ sky130_fd_sc_hd__a21bo_1
XFILLER_21_279 VGND VGND VPWR VPWR sky130_fd_sc_hd__fill_1
XFILLER_107_307 VGND VGND VPWR VPWR sky130_fd_sc_hd__decap_6
X_4666_ _0424_ _0425_ _0426_ VGND VGND VPWR VPWR _0428_ sky130_fd_sc_hd__a21oi_1
XFILLER_107_329 VGND VGND VPWR VPWR sky130_fd_sc_hd__decap_6
X_4597_ _0356_ _0357_ _0358_ VGND VGND VPWR VPWR _0360_ sky130_fd_sc_hd__nand3_1
X_3617_ _2818_ _2820_ net244 VGND VGND VPWR VPWR _2821_ sky130_fd_sc_hd__mux2_1
X_6405_ _2284_ _2289_ VGND VGND VPWR VPWR _2290_ sky130_fd_sc_hd__nand2b_1
X_3548_ net163 net260 _2314_ VGND VGND VPWR VPWR _2325_ sky130_fd_sc_hd__a21bo_1
X_6336_ _2212_ _2213_ VGND VGND VPWR VPWR _2214_ sky130_fd_sc_hd__or2_1
XFILLER_1_629 VPWR VGND VPWR VGND sky130_ef_sc_hd__decap_12
X_3479_ _0808_ _1539_ VGND VGND VPWR VPWR _1572_ sky130_fd_sc_hd__nand2_2
X_6267_ _2130_ _2137_ _2138_ VGND VGND VPWR VPWR _2140_ sky130_fd_sc_hd__nand3_2
X_5218_ _0700_ _0701_ _0993_ _0995_ VGND VGND VPWR VPWR _0996_ sky130_fd_sc_hd__o31ai_2
XFILLER_76_419 VGND VGND VPWR VPWR sky130_fd_sc_hd__fill_1
X_6198_ _2060_ _2061_ _2036_ VGND VGND VPWR VPWR _2064_ sky130_fd_sc_hd__a21o_1
X_5149_ _0908_ _0918_ _0919_ VGND VGND VPWR VPWR _0920_ sky130_fd_sc_hd__and3_1
XFILLER_84_474 VGND VGND VPWR VPWR sky130_fd_sc_hd__fill_2
XFILLER_72_625 VPWR VGND VPWR VGND sky130_ef_sc_hd__decap_12
XFILLER_71_113 VGND VGND VPWR VPWR sky130_fd_sc_hd__decap_3
XFILLER_44_327 VGND VGND VPWR VPWR sky130_fd_sc_hd__fill_1
XFILLER_72_669 VPWR VGND VPWR VGND sky130_ef_sc_hd__decap_12
XFILLER_44_349 VGND VGND VPWR VPWR sky130_fd_sc_hd__fill_1
XFILLER_25_585 VPWR VGND VPWR VGND sky130_ef_sc_hd__decap_12
XFILLER_12_257 VPWR VGND VPWR VGND sky130_ef_sc_hd__decap_12
XFILLER_40_555 VPWR VGND VPWR VGND sky130_ef_sc_hd__decap_12
XFILLER_60_44 VGND VGND VPWR VPWR sky130_fd_sc_hd__fill_1
XFILLER_8_228 VGND VGND VPWR VPWR sky130_fd_sc_hd__decap_6
XFILLER_69_20 VPWR VGND VPWR VGND sky130_ef_sc_hd__decap_12
XFILLER_5_39 VPWR VGND VPWR VGND sky130_ef_sc_hd__decap_12
XFILLER_4_445 VPWR VGND VPWR VGND sky130_ef_sc_hd__decap_12
XFILLER_4_489 VPWR VGND VPWR VGND sky130_ef_sc_hd__decap_12
XFILLER_79_246 VPWR VGND VPWR VGND sky130_ef_sc_hd__decap_12
XFILLER_94_216 VPWR VGND VPWR VGND sky130_ef_sc_hd__decap_12
XFILLER_0_673 VPWR VGND VPWR VGND sky130_ef_sc_hd__decap_12
XFILLER_94_249 VGND VGND VPWR VPWR sky130_fd_sc_hd__decap_3
XTAP_TAPCELL_ROW_89_1320 VGND VPWR sky130_fd_sc_hd__tapvpwrvgnd_1
XFILLER_85_41 VGND VGND VPWR VPWR sky130_fd_sc_hd__decap_8
XFILLER_47_110 VGND VGND VPWR VPWR sky130_fd_sc_hd__fill_2
XFILLER_85_63 VGND VGND VPWR VPWR sky130_fd_sc_hd__fill_1
XFILLER_47_132 VGND VGND VPWR VPWR sky130_fd_sc_hd__decap_8
XTAP_TAPCELL_ROW_46_801 VGND VPWR sky130_fd_sc_hd__tapvpwrvgnd_1
XFILLER_75_485 VGND VGND VPWR VPWR sky130_fd_sc_hd__decap_6
XFILLER_90_433 VPWR VGND VPWR VGND sky130_ef_sc_hd__decap_12
XFILLER_62_157 VGND VGND VPWR VPWR sky130_fd_sc_hd__fill_2
XFILLER_90_488 VGND VGND VPWR VPWR sky130_fd_sc_hd__fill_1
XFILLER_62_179 VGND VGND VPWR VPWR sky130_fd_sc_hd__decap_4
XFILLER_93_6 VPWR VGND VPWR VGND sky130_ef_sc_hd__decap_12
XFILLER_43_382 VGND VGND VPWR VPWR sky130_fd_sc_hd__decap_8
X_4520_ _0224_ _0226_ _0280_ _0281_ VGND VGND VPWR VPWR _0285_ sky130_fd_sc_hd__o211a_1
XFILLER_116_137 VGND VGND VPWR VPWR sky130_fd_sc_hd__decap_3
X_4451_ _0215_ _0216_ _0159_ _0173_ VGND VGND VPWR VPWR _0217_ sky130_fd_sc_hd__or4bb_2
XFILLER_98_533 VPWR VGND VPWR VGND sky130_ef_sc_hd__decap_12
X_4382_ _0115_ _0117_ _0114_ VGND VGND VPWR VPWR _0150_ sky130_fd_sc_hd__a21o_1
X_6121_ _1977_ _1978_ _1969_ VGND VGND VPWR VPWR _1980_ sky130_fd_sc_hd__a21o_1
XFILLER_112_365 VPWR VGND VPWR VGND sky130_ef_sc_hd__decap_12
XFILLER_100_505 VGND VGND VPWR VPWR sky130_fd_sc_hd__fill_1
XFILLER_58_419 VGND VGND VPWR VPWR sky130_fd_sc_hd__fill_1
XPHY_EDGE_ROW_7_Right_7 VGND VGND VPWR VPWR sky130_fd_sc_hd__decap_3
X_6052_ net167 net188 net343 net171 VGND VGND VPWR VPWR _1904_ sky130_fd_sc_hd__a22o_1
X_5003_ _0757_ _0758_ _0748_ VGND VGND VPWR VPWR _0761_ sky130_fd_sc_hd__a21oi_1
XFILLER_66_485 VGND VGND VPWR VPWR sky130_fd_sc_hd__decap_8
XFILLER_53_113 VPWR VGND VPWR VGND sky130_ef_sc_hd__decap_12
XFILLER_81_444 VGND VGND VPWR VPWR sky130_fd_sc_hd__decap_4
XFILLER_54_669 VPWR VGND VPWR VGND sky130_ef_sc_hd__decap_12
XFILLER_53_146 VGND VGND VPWR VPWR sky130_fd_sc_hd__decap_8
X_5905_ _1742_ _1743_ VGND VGND VPWR VPWR _1744_ sky130_fd_sc_hd__nor2_1
XFILLER_34_360 VGND VGND VPWR VPWR sky130_fd_sc_hd__fill_1
X_6885_ net181 _alu_i0.Datapath_i.fu_alu_33673_33851.out1\[11\] VGND VGND VPWR VPWR
+ _alu_i0.Datapath_i.reg_0.reg_out1\[11\] sky130_fd_sc_hd__dfxtp_1
XFILLER_14_15 VPWR VGND VPWR VGND sky130_ef_sc_hd__decap_12
XFILLER_22_511 VGND VGND VPWR VPWR sky130_fd_sc_hd__fill_1
XTAP_TAPCELL_ROW_24_539 VGND VPWR sky130_fd_sc_hd__tapvpwrvgnd_1
X_5836_ _1535_ _1536_ _1534_ VGND VGND VPWR VPWR _1669_ sky130_fd_sc_hd__a21oi_1
X_5767_ net403 net275 VGND VGND VPWR VPWR _1594_ sky130_fd_sc_hd__nand2_1
X_4718_ _0475_ _0478_ VGND VGND VPWR VPWR _0479_ sky130_fd_sc_hd__xnor2_1
X_5698_ _1394_ _1515_ _1516_ VGND VGND VPWR VPWR _1519_ sky130_fd_sc_hd__nand3_1
X_4649_ _0409_ _0410_ VGND VGND VPWR VPWR _0411_ sky130_fd_sc_hd__and2b_1
XFILLER_107_137 VGND VGND VPWR VPWR sky130_fd_sc_hd__fill_2
XTAP_TAPCELL_ROW_73_1132 VGND VPWR sky130_fd_sc_hd__tapvpwrvgnd_1
X_6319_ _2195_ _2021_ _2019_ _2030_ VGND VGND VPWR VPWR _2196_ sky130_fd_sc_hd__and4b_1
XFILLER_1_459 VGND VGND VPWR VPWR sky130_fd_sc_hd__decap_3
XFILLER_103_387 VGND VGND VPWR VPWR sky130_fd_sc_hd__decap_4
XFILLER_29_110 VGND VGND VPWR VPWR sky130_fd_sc_hd__fill_2
XFILLER_57_463 VGND VGND VPWR VPWR sky130_fd_sc_hd__fill_2
XFILLER_72_411 VGND VGND VPWR VPWR sky130_fd_sc_hd__decap_8
XTAP_TAPCELL_ROW_4_297 VGND VPWR sky130_fd_sc_hd__tapvpwrvgnd_1
XFILLER_17_327 VGND VGND VPWR VPWR sky130_fd_sc_hd__decap_3
XFILLER_72_433 VPWR VGND VPWR VGND sky130_ef_sc_hd__decap_12
XFILLER_55_55 VGND VGND VPWR VPWR sky130_fd_sc_hd__fill_1
XTAP_TAPCELL_ROW_84_1261 VGND VPWR sky130_fd_sc_hd__tapvpwrvgnd_1
XFILLER_53_691 VGND VGND VPWR VPWR sky130_fd_sc_hd__fill_1
XFILLER_13_533 VGND VGND VPWR VPWR sky130_fd_sc_hd__fill_1
XFILLER_25_393 VGND VGND VPWR VPWR sky130_fd_sc_hd__decap_8
XFILLER_9_559 VGND VGND VPWR VPWR sky130_fd_sc_hd__fill_1
XFILLER_107_671 VGND VGND VPWR VPWR sky130_fd_sc_hd__fill_1
XTAP_TAPCELL_ROW_95_1390 VGND VPWR sky130_fd_sc_hd__tapvpwrvgnd_1
XFILLER_4_253 VGND VGND VPWR VPWR sky130_fd_sc_hd__decap_8
XFILLER_106_181 VGND VGND VPWR VPWR sky130_fd_sc_hd__fill_2
XFILLER_48_441 VPWR VGND VPWR VGND sky130_ef_sc_hd__decap_12
XFILLER_82_219 VGND VGND VPWR VPWR sky130_fd_sc_hd__decap_8
XFILLER_36_669 VPWR VGND VPWR VGND sky130_ef_sc_hd__decap_12
XFILLER_63_477 VGND VGND VPWR VPWR sky130_fd_sc_hd__fill_1
X_3951_ net166 net304 VGND VGND VPWR VPWR _3141_ sky130_fd_sc_hd__or2_1
XFILLER_51_606 VGND VGND VPWR VPWR sky130_fd_sc_hd__decap_8
XFILLER_51_617 VPWR VGND VPWR VGND sky130_ef_sc_hd__decap_12
XFILLER_90_285 VGND VGND VPWR VPWR sky130_fd_sc_hd__decap_3
X_3882_ _3072_ _3074_ VGND VGND VPWR VPWR _3075_ sky130_fd_sc_hd__nand2_2
XTAP_TAPCELL_ROW_21_509 VGND VPWR sky130_fd_sc_hd__tapvpwrvgnd_1
X_6670_ net171 net320 _2578_ VGND VGND VPWR VPWR _2579_ sky130_fd_sc_hd__and3_1
XFILLER_31_363 VGND VGND VPWR VPWR sky130_fd_sc_hd__decap_4
XFILLER_31_374 VGND VGND VPWR VPWR sky130_fd_sc_hd__decap_4
X_5621_ _1432_ _1433_ _1396_ VGND VGND VPWR VPWR _1435_ sky130_fd_sc_hd__o21ai_1
X_5552_ net168 net212 _1357_ _1358_ VGND VGND VPWR VPWR _1359_ sky130_fd_sc_hd__a22o_1
X_4503_ _0252_ _0253_ _0266_ VGND VGND VPWR VPWR _0268_ sky130_fd_sc_hd__nand3_1
XFILLER_8_581 VGND VGND VPWR VPWR sky130_fd_sc_hd__decap_6
X_5483_ _1282_ _1283_ _1280_ VGND VGND VPWR VPWR _1284_ sky130_fd_sc_hd__a21bo_1
X_4434_ net225 net406 net398 net243 VGND VGND VPWR VPWR _0200_ sky130_fd_sc_hd__a22o_1
XFILLER_6_93 VGND VGND VPWR VPWR sky130_fd_sc_hd__fill_2
XFILLER_113_641 VPWR VGND VPWR VGND sky130_ef_sc_hd__decap_12
X_4365_ _0130_ _0131_ _0132_ VGND VGND VPWR VPWR _0133_ sky130_fd_sc_hd__nand3_1
XFILLER_113_685 VGND VGND VPWR VPWR sky130_fd_sc_hd__decap_6
X_6104_ net283 net439 _1809_ _1808_ VGND VGND VPWR VPWR _1961_ sky130_fd_sc_hd__a31o_1
XFILLER_112_195 VGND VGND VPWR VPWR sky130_fd_sc_hd__fill_1
X_4296_ _0065_ _0066_ VGND VGND VPWR VPWR _0067_ sky130_fd_sc_hd__or2_1
X_6035_ net395 net272 net269 net403 VGND VGND VPWR VPWR _1885_ sky130_fd_sc_hd__a22o_1
XFILLER_100_346 VGND VGND VPWR VPWR sky130_fd_sc_hd__decap_8
XTAP_TAPCELL_ROW_107_1537 VGND VPWR sky130_fd_sc_hd__tapvpwrvgnd_1
XTAP_TAPCELL_ROW_1_267 VGND VPWR sky130_fd_sc_hd__tapvpwrvgnd_1
XFILLER_54_477 VGND VGND VPWR VPWR sky130_fd_sc_hd__fill_2
XFILLER_25_69 VPWR VGND VPWR VGND sky130_ef_sc_hd__decap_12
XFILLER_35_691 VGND VGND VPWR VPWR sky130_fd_sc_hd__fill_1
XTAP_TAPCELL_ROW_37_697 VGND VPWR sky130_fd_sc_hd__tapvpwrvgnd_1
X_6868_ _2793_ _2795_ _alu_i0.Datapath_i.reg_0.reg_out1\[31\] net150 VGND VGND VPWR
+ VPWR net101 sky130_fd_sc_hd__a2bb2o_1
X_5819_ _1646_ _1647_ _1478_ VGND VGND VPWR VPWR _1651_ sky130_fd_sc_hd__a21oi_1
XFILLER_10_569 VPWR VGND VPWR VGND sky130_ef_sc_hd__decap_12
X_6799_ net430 net271 net268 net359 VGND VGND VPWR VPWR _2720_ sky130_fd_sc_hd__a22o_1
XFILLER_41_35 VGND VGND VPWR VPWR sky130_fd_sc_hd__decap_3
XFILLER_6_529 VGND VGND VPWR VPWR sky130_fd_sc_hd__decap_3
XTAP_TAPCELL_ROW_9_356 VGND VPWR sky130_fd_sc_hd__tapvpwrvgnd_1
XFILLER_66_10 VGND VGND VPWR VPWR sky130_fd_sc_hd__fill_1
XFILLER_1_278 VGND VGND VPWR VPWR sky130_fd_sc_hd__fill_2
XFILLER_1_289 VGND VGND VPWR VPWR sky130_fd_sc_hd__decap_8
XFILLER_2_29 VPWR VGND VPWR VGND sky130_ef_sc_hd__decap_12
XFILLER_77_558 VGND VGND VPWR VPWR sky130_fd_sc_hd__fill_2
XFILLER_18_625 VPWR VGND VPWR VGND sky130_ef_sc_hd__decap_12
XFILLER_17_113 VPWR VGND VPWR VGND sky130_ef_sc_hd__decap_12
XFILLER_18_669 VPWR VGND VPWR VGND sky130_ef_sc_hd__decap_12
XFILLER_17_179 VGND VGND VPWR VPWR sky130_fd_sc_hd__decap_8
XFILLER_33_617 VPWR VGND VPWR VGND sky130_ef_sc_hd__decap_12
XFILLER_45_477 VGND VGND VPWR VPWR sky130_fd_sc_hd__fill_1
XFILLER_72_274 VPWR VGND VPWR VGND sky130_ef_sc_hd__decap_12
XFILLER_9_345 VPWR VGND VPWR VGND sky130_ef_sc_hd__decap_12
Xoutput108 net108 VGND VGND VPWR VPWR return_port[9] sky130_fd_sc_hd__clkbuf_4
XFILLER_5_573 VPWR VGND VPWR VGND sky130_ef_sc_hd__decap_12
XFILLER_99_138 VGND VGND VPWR VPWR sky130_fd_sc_hd__fill_2
X_4150_ net435 net255 VGND VGND VPWR VPWR _3331_ sky130_fd_sc_hd__nand2_1
Xoutput90 net90 VGND VGND VPWR VPWR return_port[21] sky130_fd_sc_hd__clkbuf_4
XFILLER_95_355 VPWR VGND VPWR VGND sky130_ef_sc_hd__decap_12
XFILLER_95_344 VGND VGND VPWR VPWR sky130_fd_sc_hd__decap_4
X_4081_ net440 net267 VGND VGND VPWR VPWR _3265_ sky130_fd_sc_hd__and2_1
XFILLER_83_517 VGND VGND VPWR VPWR sky130_fd_sc_hd__fill_1
XFILLER_91_561 VGND VGND VPWR VPWR sky130_fd_sc_hd__decap_4
XFILLER_36_477 VGND VGND VPWR VPWR sky130_fd_sc_hd__decap_8
X_4983_ _0737_ _0738_ _0739_ VGND VGND VPWR VPWR _0741_ sky130_fd_sc_hd__a21oi_1
XFILLER_17_691 VGND VGND VPWR VPWR sky130_fd_sc_hd__fill_1
XFILLER_16_190 VGND VGND VPWR VPWR sky130_fd_sc_hd__decap_6
X_6722_ _2462_ _2465_ _2634_ _2635_ VGND VGND VPWR VPWR _2636_ sky130_fd_sc_hd__o211ai_1
XTAP_TAPCELL_ROW_34_656 VGND VPWR sky130_fd_sc_hd__tapvpwrvgnd_1
X_3934_ net176 _0950_ _3124_ VGND VGND VPWR VPWR _3125_ sky130_fd_sc_hd__a21oi_1
XTAP_TAPCELL_ROW_102_1478 VGND VPWR sky130_fd_sc_hd__tapvpwrvgnd_1
XTAP_TAPCELL_ROW_62_998 VGND VPWR sky130_fd_sc_hd__tapvpwrvgnd_1
X_3865_ _3036_ _3051_ _3056_ _3058_ VGND VGND VPWR VPWR _3059_ sky130_fd_sc_hd__a31o_1
X_6653_ net442 net193 VGND VGND VPWR VPWR _2560_ sky130_fd_sc_hd__nand2_1
X_5604_ net388 net375 net315 net307 VGND VGND VPWR VPWR _1416_ sky130_fd_sc_hd__nand4_1
X_3796_ _2981_ _2992_ net143 VGND VGND VPWR VPWR _2993_ sky130_fd_sc_hd__mux2_1
X_6584_ _2483_ _2484_ _2313_ _2316_ VGND VGND VPWR VPWR _2486_ sky130_fd_sc_hd__o211a_1
XFILLER_11_27 VPWR VGND VPWR VGND sky130_ef_sc_hd__decap_12
X_5535_ net247 net450 VGND VGND VPWR VPWR _1340_ sky130_fd_sc_hd__nand2_1
XFILLER_105_427 VGND VGND VPWR VPWR sky130_fd_sc_hd__decap_8
X_5466_ net411 net299 net294 net420 VGND VGND VPWR VPWR _1265_ sky130_fd_sc_hd__a22o_1
XFILLER_105_438 VGND VGND VPWR VPWR sky130_fd_sc_hd__decap_8
X_4417_ _0182_ _0183_ VGND VGND VPWR VPWR _0184_ sky130_fd_sc_hd__nand2_1
X_5397_ _1152_ _1188_ _1189_ VGND VGND VPWR VPWR _1191_ sky130_fd_sc_hd__and3_1
Xfanout313 net4 VGND VGND VPWR VPWR net313 sky130_fd_sc_hd__buf_4
XTAP_TAPCELL_ROW_6_326 VGND VPWR sky130_fd_sc_hd__tapvpwrvgnd_1
Xfanout302 net304 VGND VGND VPWR VPWR net302 sky130_fd_sc_hd__clkbuf_4
Xfanout335 net36 VGND VGND VPWR VPWR net335 sky130_fd_sc_hd__clkbuf_4
XFILLER_98_171 VGND VGND VPWR VPWR sky130_fd_sc_hd__fill_2
X_4348_ _0065_ _0069_ _0087_ VGND VGND VPWR VPWR _0117_ sky130_fd_sc_hd__o21a_1
Xfanout357 net358 VGND VGND VPWR VPWR net357 sky130_fd_sc_hd__buf_2
Xfanout324 net326 VGND VGND VPWR VPWR net324 sky130_fd_sc_hd__buf_2
Xfanout346 net348 VGND VGND VPWR VPWR net346 sky130_fd_sc_hd__clkbuf_4
XFILLER_100_121 VGND VGND VPWR VPWR sky130_fd_sc_hd__fill_2
X_4279_ _1865_ _0049_ _0050_ VGND VGND VPWR VPWR _0051_ sky130_fd_sc_hd__a21oi_1
Xfanout379 net381 VGND VGND VPWR VPWR net379 sky130_fd_sc_hd__clkbuf_4
XFILLER_59_558 VGND VGND VPWR VPWR sky130_fd_sc_hd__fill_2
Xfanout368 net369 VGND VGND VPWR VPWR net368 sky130_fd_sc_hd__clkbuf_4
XFILLER_86_388 VPWR VGND VPWR VGND sky130_ef_sc_hd__decap_12
XFILLER_74_517 VGND VGND VPWR VPWR sky130_fd_sc_hd__fill_1
X_6018_ _1864_ _1866_ VGND VGND VPWR VPWR _1867_ sky130_fd_sc_hd__nor2_1
XFILLER_27_411 VGND VGND VPWR VPWR sky130_fd_sc_hd__fill_1
XFILLER_46_219 VGND VGND VPWR VPWR sky130_fd_sc_hd__decap_4
XFILLER_54_230 VGND VGND VPWR VPWR sky130_fd_sc_hd__decap_8
XTAP_TAPCELL_ROW_68_1064 VGND VPWR sky130_fd_sc_hd__tapvpwrvgnd_1
XFILLER_15_617 VPWR VGND VPWR VGND sky130_ef_sc_hd__decap_12
XFILLER_14_116 VPWR VGND VPWR VGND sky130_ef_sc_hd__decap_12
XTAP_TAPCELL_ROW_81_1220 VGND VPWR sky130_fd_sc_hd__tapvpwrvgnd_1
XFILLER_14_138 VGND VGND VPWR VPWR sky130_fd_sc_hd__fill_2
XFILLER_30_609 VPWR VGND VPWR VGND sky130_ef_sc_hd__decap_12
XFILLER_10_322 VPWR VGND VPWR VGND sky130_ef_sc_hd__decap_12
XFILLER_22_171 VPWR VGND VPWR VGND sky130_ef_sc_hd__decap_12
XFILLER_108_210 VGND VGND VPWR VPWR sky130_fd_sc_hd__fill_1
XFILLER_10_377 VGND VGND VPWR VPWR sky130_fd_sc_hd__decap_8
XFILLER_10_399 VGND VGND VPWR VPWR sky130_fd_sc_hd__fill_2
XFILLER_108_276 VGND VGND VPWR VPWR sky130_fd_sc_hd__decap_8
XFILLER_97_609 VGND VGND VPWR VPWR sky130_fd_sc_hd__decap_6
XTAP_TAPCELL_ROW_92_1360 VGND VPWR sky130_fd_sc_hd__tapvpwrvgnd_1
XFILLER_104_460 VPWR VGND VPWR VGND sky130_ef_sc_hd__decap_12
XFILLER_89_160 VGND VGND VPWR VPWR sky130_fd_sc_hd__decap_8
XFILLER_2_587 VGND VGND VPWR VPWR sky130_fd_sc_hd__fill_1
XFILLER_89_193 VGND VGND VPWR VPWR sky130_fd_sc_hd__fill_1
XFILLER_77_333 VGND VGND VPWR VPWR sky130_fd_sc_hd__decap_3
XFILLER_92_303 VGND VGND VPWR VPWR sky130_fd_sc_hd__decap_4
XFILLER_65_517 VPWR VGND VPWR VGND sky130_ef_sc_hd__decap_12
XFILLER_93_30 VPWR VGND VPWR VGND sky130_ef_sc_hd__decap_12
XFILLER_73_561 VGND VGND VPWR VPWR sky130_fd_sc_hd__decap_3
XFILLER_45_241 VPWR VGND VPWR VGND sky130_ef_sc_hd__decap_12
XFILLER_13_160 VGND VGND VPWR VPWR sky130_fd_sc_hd__fill_1
XTAP_TAPCELL_ROW_31_626 VGND VPWR sky130_fd_sc_hd__tapvpwrvgnd_1
X_3650_ _2849_ net140 _2848_ VGND VGND VPWR VPWR _2853_ sky130_fd_sc_hd__or3b_1
X_3581_ net244 _2673_ VGND VGND VPWR VPWR _2684_ sky130_fd_sc_hd__or2_1
XTAP_TAPCELL_ROW_11_383 VGND VPWR sky130_fd_sc_hd__tapvpwrvgnd_1
X_5320_ net169 _1105_ _1104_ VGND VGND VPWR VPWR _1106_ sky130_fd_sc_hd__a21bo_1
X_5251_ _1028_ _1029_ _0921_ _0923_ VGND VGND VPWR VPWR _1031_ sky130_fd_sc_hd__o211ai_2
X_4202_ net144 _3374_ _3380_ VGND VGND VPWR VPWR _3381_ sky130_fd_sc_hd__or3_1
X_5182_ _0945_ _0955_ VGND VGND VPWR VPWR _0956_ sky130_fd_sc_hd__xnor2_1
X_4133_ _3285_ _3290_ _3312_ _3313_ VGND VGND VPWR VPWR _3315_ sky130_fd_sc_hd__and4_1
XFILLER_110_474 VGND VGND VPWR VPWR sky130_fd_sc_hd__fill_2
XFILLER_28_219 VGND VGND VPWR VPWR sky130_fd_sc_hd__decap_3
XTAP_TAPCELL_ROW_39_715 VGND VPWR sky130_fd_sc_hd__tapvpwrvgnd_1
X_4064_ _3224_ _3230_ _3248_ VGND VGND VPWR VPWR _3249_ sky130_fd_sc_hd__a21o_1
XTAP_TAPCELL_ROW_19_483 VGND VPWR sky130_fd_sc_hd__tapvpwrvgnd_1
XFILLER_36_274 VGND VGND VPWR VPWR sky130_fd_sc_hd__fill_1
XFILLER_91_391 VGND VGND VPWR VPWR sky130_fd_sc_hd__fill_1
X_4966_ _0722_ _0723_ VGND VGND VPWR VPWR _0724_ sky130_fd_sc_hd__and2b_1
X_6705_ _2215_ _2616_ VGND VGND VPWR VPWR _2617_ sky130_fd_sc_hd__xor2_2
XFILLER_51_277 VGND VGND VPWR VPWR sky130_fd_sc_hd__decap_3
X_4897_ _0654_ _0655_ VGND VGND VPWR VPWR _0656_ sky130_fd_sc_hd__nor2_1
X_3917_ net129 _3097_ _3107_ net122 VGND VGND VPWR VPWR _3109_ sky130_fd_sc_hd__a2bb2o_1
XFILLER_22_15 VPWR VGND VPWR VGND sky130_ef_sc_hd__decap_12
X_3848_ net246 _1593_ _2862_ net154 VGND VGND VPWR VPWR _3043_ sky130_fd_sc_hd__a211o_1
X_6636_ _2532_ _2539_ VGND VGND VPWR VPWR _2541_ sky130_fd_sc_hd__nor2_1
X_3779_ net153 _2975_ _2976_ VGND VGND VPWR VPWR _2977_ sky130_fd_sc_hd__a21o_1
X_6567_ _2296_ _2298_ _2465_ _2466_ VGND VGND VPWR VPWR _2468_ sky130_fd_sc_hd__a211o_1
XTAP_TAPCELL_ROW_115_1636 VGND VPWR sky130_fd_sc_hd__tapvpwrvgnd_1
X_5518_ _1318_ _1319_ _1193_ net111 VGND VGND VPWR VPWR _1323_ sky130_fd_sc_hd__a211o_1
XFILLER_105_213 VGND VGND VPWR VPWR sky130_fd_sc_hd__decap_8
XFILLER_3_329 VGND VGND VPWR VPWR sky130_fd_sc_hd__decap_6
X_6498_ net171 net166 net329 net323 VGND VGND VPWR VPWR _2392_ sky130_fd_sc_hd__and4_1
X_5449_ _1126_ _1129_ _1243_ _1245_ VGND VGND VPWR VPWR _1247_ sky130_fd_sc_hd__a211o_1
XFILLER_99_480 VPWR VGND VPWR VGND sky130_ef_sc_hd__decap_12
Xfanout121 net122 VGND VGND VPWR VPWR net121 sky130_fd_sc_hd__clkbuf_2
XFILLER_87_653 VPWR VGND VPWR VGND sky130_ef_sc_hd__decap_12
Xfanout165 _0765_ VGND VGND VPWR VPWR net165 sky130_fd_sc_hd__buf_2
Xfanout154 net156 VGND VGND VPWR VPWR net154 sky130_fd_sc_hd__buf_2
Xfanout132 net133 VGND VGND VPWR VPWR net132 sky130_fd_sc_hd__clkbuf_4
Xfanout143 _1146_ VGND VGND VPWR VPWR net143 sky130_fd_sc_hd__clkbuf_2
XFILLER_74_303 VGND VGND VPWR VPWR sky130_fd_sc_hd__decap_4
Xfanout187 net188 VGND VGND VPWR VPWR net187 sky130_fd_sc_hd__dlymetal6s2s_1
Xfanout198 net200 VGND VGND VPWR VPWR net198 sky130_fd_sc_hd__buf_2
XFILLER_47_34 VPWR VGND VPWR VGND sky130_ef_sc_hd__decap_12
Xfanout176 net177 VGND VGND VPWR VPWR net176 sky130_fd_sc_hd__clkbuf_4
XFILLER_74_347 VPWR VGND VPWR VGND sky130_ef_sc_hd__decap_12
XFILLER_47_89 VGND VGND VPWR VPWR sky130_fd_sc_hd__fill_2
XFILLER_103_51 VGND VGND VPWR VPWR sky130_fd_sc_hd__decap_4
XFILLER_55_583 VPWR VGND VPWR VGND sky130_ef_sc_hd__decap_12
XFILLER_63_44 VPWR VGND VPWR VGND sky130_ef_sc_hd__decap_12
XFILLER_15_447 VGND VGND VPWR VPWR sky130_fd_sc_hd__fill_1
XFILLER_42_244 VGND VGND VPWR VPWR sky130_fd_sc_hd__decap_8
XFILLER_63_99 VPWR VGND VPWR VGND sky130_ef_sc_hd__decap_12
XFILLER_11_653 VPWR VGND VPWR VGND sky130_ef_sc_hd__decap_12
XFILLER_10_141 VGND VGND VPWR VPWR sky130_fd_sc_hd__fill_2
XFILLER_6_101 VPWR VGND VPWR VGND sky130_ef_sc_hd__decap_12
XFILLER_109_585 VPWR VGND VPWR VGND sky130_ef_sc_hd__decap_12
XFILLER_6_178 VGND VGND VPWR VPWR sky130_fd_sc_hd__fill_1
XFILLER_97_417 VPWR VGND VPWR VGND sky130_ef_sc_hd__decap_12
XFILLER_40_9 VPWR VGND VPWR VGND sky130_ef_sc_hd__decap_12
XFILLER_77_152 VGND VGND VPWR VPWR sky130_fd_sc_hd__decap_4
XFILLER_65_314 VPWR VGND VPWR VGND sky130_ef_sc_hd__decap_12
XFILLER_92_166 VGND VGND VPWR VPWR sky130_fd_sc_hd__decap_8
XFILLER_80_306 VGND VGND VPWR VPWR sky130_fd_sc_hd__fill_2
XFILLER_18_285 VGND VGND VPWR VPWR sky130_fd_sc_hd__fill_1
XFILLER_33_211 VPWR VGND VPWR VGND sky130_ef_sc_hd__decap_12
X_4820_ _0508_ _0511_ VGND VGND VPWR VPWR _0580_ sky130_fd_sc_hd__nand2_1
XFILLER_61_553 VGND VGND VPWR VPWR sky130_fd_sc_hd__decap_6
XTAP_TAPCELL_ROW_16_442 VGND VPWR sky130_fd_sc_hd__tapvpwrvgnd_1
XFILLER_33_233 VGND VGND VPWR VPWR sky130_fd_sc_hd__fill_2
XTAP_TAPCELL_ROW_44_784 VGND VPWR sky130_fd_sc_hd__tapvpwrvgnd_1
X_4751_ _0507_ _0510_ _0511_ VGND VGND VPWR VPWR _0512_ sky130_fd_sc_hd__nand3_1
X_4682_ _0442_ _0443_ _0436_ VGND VGND VPWR VPWR _0444_ sky130_fd_sc_hd__a21o_1
X_3702_ _2901_ _2902_ _2896_ VGND VGND VPWR VPWR _2903_ sky130_fd_sc_hd__a21oi_1
X_3633_ _2836_ _2456_ net285 VGND VGND VPWR VPWR _2837_ sky130_fd_sc_hd__mux2_1
X_6421_ _2305_ _2306_ _2147_ _2149_ VGND VGND VPWR VPWR _2308_ sky130_fd_sc_hd__a211o_1
XFILLER_108_29 VPWR VGND VPWR VGND sky130_ef_sc_hd__decap_12
X_3564_ _1321_ _1353_ net282 VGND VGND VPWR VPWR _2498_ sky130_fd_sc_hd__mux2_1
X_6352_ _2230_ _2231_ VGND VGND VPWR VPWR _2232_ sky130_fd_sc_hd__nor2_1
X_3495_ net355 net398 VGND VGND VPWR VPWR _1746_ sky130_fd_sc_hd__and2_1
X_5303_ _1085_ _1086_ _0932_ _0934_ VGND VGND VPWR VPWR _1088_ sky130_fd_sc_hd__o211a_1
X_6283_ _2110_ _2111_ _2155_ _2156_ VGND VGND VPWR VPWR _2157_ sky130_fd_sc_hd__nand4_2
X_5234_ _1310_ _1011_ VGND VGND VPWR VPWR _1012_ sky130_fd_sc_hd__xnor2_1
XTAP_TAPCELL_ROW_110_1566 VGND VPWR sky130_fd_sc_hd__tapvpwrvgnd_1
XFILLER_69_653 VPWR VGND VPWR VGND sky130_ef_sc_hd__decap_12
X_5165_ net469 net453 net303 net300 VGND VGND VPWR VPWR _0937_ sky130_fd_sc_hd__and4_1
XTAP_TAPCELL_ROW_110_1577 VGND VPWR sky130_fd_sc_hd__tapvpwrvgnd_1
XFILLER_56_303 VGND VGND VPWR VPWR sky130_fd_sc_hd__decap_4
X_4116_ _3215_ _3233_ _3297_ _3298_ VGND VGND VPWR VPWR _3299_ sky130_fd_sc_hd__a31o_1
X_5096_ _0755_ _0758_ _0860_ _0861_ VGND VGND VPWR VPWR _0862_ sky130_fd_sc_hd__a211oi_4
XFILLER_84_645 VPWR VGND VPWR VGND sky130_ef_sc_hd__decap_12
XFILLER_84_689 VGND VGND VPWR VPWR sky130_fd_sc_hd__decap_3
XFILLER_17_15 VPWR VGND VPWR VGND sky130_ef_sc_hd__decap_12
XFILLER_37_561 VGND VGND VPWR VPWR sky130_fd_sc_hd__decap_6
X_4047_ net274 net448 VGND VGND VPWR VPWR _3233_ sky130_fd_sc_hd__nand2b_1
XFILLER_83_177 VPWR VGND VPWR VGND sky130_ef_sc_hd__decap_12
XTAP_TAPCELL_ROW_65_1034 VGND VPWR sky130_fd_sc_hd__tapvpwrvgnd_1
X_5998_ _1799_ _1800_ _1843_ _1845_ VGND VGND VPWR VPWR _1846_ sky130_fd_sc_hd__nand4_4
X_4949_ net425 net321 VGND VGND VPWR VPWR _0707_ sky130_fd_sc_hd__nand2_1
XFILLER_24_299 VGND VGND VPWR VPWR sky130_fd_sc_hd__fill_1
XFILLER_33_69 VPWR VGND VPWR VGND sky130_ef_sc_hd__decap_12
X_6619_ _2507_ _2521_ VGND VGND VPWR VPWR _2523_ sky130_fd_sc_hd__nand2_1
XFILLER_20_461 VGND VGND VPWR VPWR sky130_fd_sc_hd__fill_1
XFILLER_20_494 VGND VGND VPWR VPWR sky130_fd_sc_hd__decap_8
XFILLER_106_533 VPWR VGND VPWR VGND sky130_ef_sc_hd__decap_12
XFILLER_106_511 VPWR VGND VPWR VGND sky130_ef_sc_hd__decap_12
XTAP_TAPCELL_ROW_76_1163 VGND VPWR sky130_fd_sc_hd__tapvpwrvgnd_1
XFILLER_79_417 VPWR VGND VPWR VGND sky130_ef_sc_hd__decap_12
XFILLER_87_461 VPWR VGND VPWR VGND sky130_ef_sc_hd__decap_12
XFILLER_58_77 VGND VGND VPWR VPWR sky130_fd_sc_hd__decap_6
XFILLER_114_83 VGND VGND VPWR VPWR sky130_fd_sc_hd__fill_1
XFILLER_74_21 VGND VGND VPWR VPWR sky130_fd_sc_hd__decap_6
XFILLER_90_637 VGND VGND VPWR VPWR sky130_fd_sc_hd__decap_6
XFILLER_15_211 VPWR VGND VPWR VGND sky130_ef_sc_hd__decap_12
XTAP_TAPCELL_ROW_87_1292 VGND VPWR sky130_fd_sc_hd__tapvpwrvgnd_1
XFILLER_43_586 VPWR VGND VPWR VGND sky130_ef_sc_hd__decap_12
XTAP_TAPCELL_ROW_13_412 VGND VPWR sky130_fd_sc_hd__tapvpwrvgnd_1
XFILLER_15_299 VGND VGND VPWR VPWR sky130_fd_sc_hd__decap_3
XFILLER_88_9 VGND VGND VPWR VPWR sky130_fd_sc_hd__decap_3
XTAP_TAPCELL_ROW_41_743 VGND VPWR sky130_fd_sc_hd__tapvpwrvgnd_1
XFILLER_7_421 VGND VGND VPWR VPWR sky130_fd_sc_hd__fill_1
XFILLER_116_319 VGND VGND VPWR VPWR sky130_fd_sc_hd__decap_4
XFILLER_11_494 VGND VGND VPWR VPWR sky130_fd_sc_hd__decap_8
XFILLER_99_51 VGND VGND VPWR VPWR sky130_fd_sc_hd__decap_4
XFILLER_99_84 VGND VGND VPWR VPWR sky130_fd_sc_hd__decap_8
XFILLER_112_525 VGND VGND VPWR VPWR sky130_fd_sc_hd__decap_6
XFILLER_97_225 VPWR VGND VPWR VGND sky130_ef_sc_hd__decap_12
XFILLER_3_671 VGND VGND VPWR VPWR sky130_fd_sc_hd__fill_1
XFILLER_112_569 VPWR VGND VPWR VGND sky130_ef_sc_hd__decap_12
XFILLER_66_645 VPWR VGND VPWR VGND sky130_ef_sc_hd__decap_12
XFILLER_17_3 VPWR VGND VPWR VGND sky130_ef_sc_hd__decap_12
XTAP_TAPCELL_ROW_49_843 VGND VPWR sky130_fd_sc_hd__tapvpwrvgnd_1
XFILLER_66_689 VGND VGND VPWR VPWR sky130_fd_sc_hd__decap_3
XFILLER_65_133 VPWR VGND VPWR VGND sky130_ef_sc_hd__decap_12
XFILLER_93_486 VPWR VGND VPWR VGND sky130_ef_sc_hd__decap_12
XFILLER_65_188 VPWR VGND VPWR VGND sky130_ef_sc_hd__decap_12
XFILLER_19_561 VGND VGND VPWR VPWR sky130_fd_sc_hd__decap_8
X_5921_ net168 net192 VGND VGND VPWR VPWR _1762_ sky130_fd_sc_hd__nand2_1
XFILLER_80_147 VGND VGND VPWR VPWR sky130_fd_sc_hd__fill_1
XFILLER_19_594 VPWR VGND VPWR VGND sky130_ef_sc_hd__decap_12
XFILLER_61_361 VPWR VGND VPWR VGND sky130_ef_sc_hd__decap_12
X_5852_ _1684_ _1685_ _1676_ VGND VGND VPWR VPWR _1687_ sky130_fd_sc_hd__a21o_1
X_4803_ net290 net260 VGND VGND VPWR VPWR _0563_ sky130_fd_sc_hd__nand2_1
X_5783_ _1589_ _1609_ VGND VGND VPWR VPWR _1611_ sky130_fd_sc_hd__xnor2_1
XFILLER_21_225 VGND VGND VPWR VPWR sky130_fd_sc_hd__decap_4
XFILLER_21_236 VGND VGND VPWR VPWR sky130_fd_sc_hd__decap_8
X_4734_ _0491_ _0492_ _0493_ VGND VGND VPWR VPWR _0495_ sky130_fd_sc_hd__nand3_1
X_4665_ _0424_ _0425_ _0426_ VGND VGND VPWR VPWR _0427_ sky130_fd_sc_hd__and3_1
X_4596_ _0357_ _0358_ _0356_ VGND VGND VPWR VPWR _0359_ sky130_fd_sc_hd__a21o_1
X_6404_ _2287_ _2288_ VGND VGND VPWR VPWR _2289_ sky130_fd_sc_hd__xnor2_1
X_3616_ net277 _2161_ _2819_ VGND VGND VPWR VPWR _2820_ sky130_fd_sc_hd__a21oi_1
X_3547_ net356 net220 VGND VGND VPWR VPWR _2314_ sky130_fd_sc_hd__nand2_2
X_6335_ _2202_ _2211_ VGND VGND VPWR VPWR _2213_ sky130_fd_sc_hd__nor2_1
X_3478_ net226 _1550_ VGND VGND VPWR VPWR _1561_ sky130_fd_sc_hd__nor2_1
X_6266_ _2135_ _2136_ _2131_ VGND VGND VPWR VPWR _2138_ sky130_fd_sc_hd__a21o_1
X_5217_ _0789_ _0884_ _0886_ VGND VGND VPWR VPWR _0995_ sky130_fd_sc_hd__o21a_1
XFILLER_69_461 VPWR VGND VPWR VGND sky130_ef_sc_hd__decap_12
X_6197_ _2036_ _2060_ _2061_ VGND VGND VPWR VPWR _2063_ sky130_fd_sc_hd__nand3_2
X_5148_ _0909_ _0915_ _0916_ VGND VGND VPWR VPWR _0919_ sky130_fd_sc_hd__nand3_2
XFILLER_56_100 VPWR VGND VPWR VGND sky130_ef_sc_hd__decap_12
XFILLER_29_314 VPWR VGND VPWR VGND sky130_ef_sc_hd__decap_12
X_5079_ _0831_ _0843_ VGND VGND VPWR VPWR _0844_ sky130_fd_sc_hd__and2b_1
XFILLER_29_369 VGND VGND VPWR VPWR sky130_fd_sc_hd__decap_3
XFILLER_72_637 VGND VGND VPWR VPWR sky130_fd_sc_hd__decap_6
XFILLER_37_391 VGND VGND VPWR VPWR sky130_fd_sc_hd__fill_1
XFILLER_44_68 VPWR VGND VPWR VGND sky130_ef_sc_hd__decap_12
XFILLER_80_681 VGND VGND VPWR VPWR sky130_fd_sc_hd__decap_8
XFILLER_25_597 VPWR VGND VPWR VGND sky130_ef_sc_hd__decap_12
XFILLER_100_41 VPWR VGND VPWR VGND sky130_ef_sc_hd__decap_12
XFILLER_12_269 VPWR VGND VPWR VGND sky130_ef_sc_hd__decap_12
XFILLER_100_85 VPWR VGND VPWR VGND sky130_ef_sc_hd__decap_12
XFILLER_100_74 VGND VGND VPWR VPWR sky130_fd_sc_hd__decap_8
XFILLER_69_32 VPWR VGND VPWR VGND sky130_ef_sc_hd__decap_12
XFILLER_4_457 VPWR VGND VPWR VGND sky130_ef_sc_hd__decap_12
XFILLER_109_94 VGND VGND VPWR VPWR sky130_fd_sc_hd__decap_6
XFILLER_69_65 VPWR VGND VPWR VGND sky130_ef_sc_hd__decap_12
XFILLER_106_396 VGND VGND VPWR VPWR sky130_fd_sc_hd__decap_3
XFILLER_79_258 VGND VGND VPWR VPWR sky130_fd_sc_hd__fill_1
XFILLER_79_225 VGND VGND VPWR VPWR sky130_fd_sc_hd__fill_2
XFILLER_0_641 VGND VGND VPWR VPWR sky130_fd_sc_hd__decap_3
XFILLER_48_601 VGND VGND VPWR VPWR sky130_fd_sc_hd__decap_3
XFILLER_48_612 VPWR VGND VPWR VGND sky130_ef_sc_hd__decap_12
XFILLER_94_228 VGND VGND VPWR VPWR sky130_fd_sc_hd__decap_4
XTAP_TAPCELL_ROW_89_1321 VGND VPWR sky130_fd_sc_hd__tapvpwrvgnd_1
XFILLER_0_685 VGND VGND VPWR VPWR sky130_fd_sc_hd__decap_6
XFILLER_48_645 VPWR VGND VPWR VGND sky130_ef_sc_hd__decap_12
XFILLER_90_401 VPWR VGND VPWR VGND sky130_ef_sc_hd__decap_12
XFILLER_47_188 VPWR VGND VPWR VGND sky130_ef_sc_hd__decap_12
XTAP_TAPCELL_ROW_46_802 VGND VPWR sky130_fd_sc_hd__tapvpwrvgnd_1
XFILLER_48_689 VGND VGND VPWR VPWR sky130_fd_sc_hd__decap_3
XFILLER_90_445 VGND VGND VPWR VPWR sky130_fd_sc_hd__fill_2
XFILLER_62_136 VGND VGND VPWR VPWR sky130_fd_sc_hd__decap_4
XFILLER_16_531 VGND VGND VPWR VPWR sky130_fd_sc_hd__fill_1
XFILLER_71_670 VGND VGND VPWR VPWR sky130_fd_sc_hd__fill_2
XFILLER_43_361 VGND VGND VPWR VPWR sky130_fd_sc_hd__decap_8
XFILLER_31_512 VGND VGND VPWR VPWR sky130_fd_sc_hd__fill_1
X_4450_ _0213_ _0214_ _0198_ VGND VGND VPWR VPWR _0216_ sky130_fd_sc_hd__a21oi_1
XFILLER_7_251 VGND VGND VPWR VPWR sky130_fd_sc_hd__decap_8
XFILLER_116_149 VGND VGND VPWR VPWR sky130_fd_sc_hd__decap_3
X_4381_ _0147_ _0148_ VGND VGND VPWR VPWR _0149_ sky130_fd_sc_hd__nand2b_1
XFILLER_98_501 VPWR VGND VPWR VGND sky130_ef_sc_hd__decap_12
X_6120_ _1969_ _1977_ _1978_ VGND VGND VPWR VPWR _1979_ sky130_fd_sc_hd__nand3_2
XFILLER_98_545 VPWR VGND VPWR VGND sky130_ef_sc_hd__decap_12
XFILLER_112_377 VPWR VGND VPWR VGND sky130_ef_sc_hd__decap_12
XFILLER_98_589 VPWR VGND VPWR VGND sky130_ef_sc_hd__decap_12
XFILLER_85_206 VGND VGND VPWR VPWR sky130_fd_sc_hd__fill_2
X_6051_ net171 net167 net188 net340 VGND VGND VPWR VPWR _1903_ sky130_fd_sc_hd__and4_1
X_5002_ _0759_ VGND VGND VPWR VPWR _0760_ sky130_fd_sc_hd__inv_2
XFILLER_81_412 VGND VGND VPWR VPWR sky130_fd_sc_hd__fill_2
XFILLER_53_125 VGND VGND VPWR VPWR sky130_fd_sc_hd__decap_8
X_6884_ net181 _alu_i0.Datapath_i.fu_alu_33673_33851.out1\[10\] VGND VGND VPWR VPWR
+ _alu_i0.Datapath_i.reg_0.reg_out1\[10\] sky130_fd_sc_hd__dfxtp_1
X_5904_ _1740_ _1741_ VGND VGND VPWR VPWR _1743_ sky130_fd_sc_hd__and2b_1
XFILLER_53_169 VGND VGND VPWR VPWR sky130_fd_sc_hd__fill_2
XFILLER_62_681 VGND VGND VPWR VPWR sky130_fd_sc_hd__decap_8
XFILLER_61_180 VGND VGND VPWR VPWR sky130_fd_sc_hd__decap_8
XFILLER_14_27 VGND VGND VPWR VPWR sky130_fd_sc_hd__fill_1
X_5835_ _1666_ _1667_ VGND VGND VPWR VPWR _1668_ sky130_fd_sc_hd__xnor2_1
X_5766_ _1590_ _1591_ VGND VGND VPWR VPWR _1592_ sky130_fd_sc_hd__and2b_1
XFILLER_22_589 VPWR VGND VPWR VGND sky130_ef_sc_hd__decap_12
X_4717_ _0476_ _0477_ VGND VGND VPWR VPWR _0478_ sky130_fd_sc_hd__and2b_1
X_5697_ _1394_ _1515_ _1516_ VGND VGND VPWR VPWR _1518_ sky130_fd_sc_hd__and3_1
X_4648_ net417 net190 net344 net424 VGND VGND VPWR VPWR _0410_ sky130_fd_sc_hd__a22o_1
XFILLER_30_15 VPWR VGND VPWR VGND sky130_ef_sc_hd__decap_12
XFILLER_115_160 VGND VGND VPWR VPWR sky130_fd_sc_hd__decap_4
X_4579_ _0341_ _0342_ VGND VGND VPWR VPWR _0343_ sky130_fd_sc_hd__xor2_1
XTAP_TAPCELL_ROW_73_1122 VGND VPWR sky130_fd_sc_hd__tapvpwrvgnd_1
XFILLER_115_193 VGND VGND VPWR VPWR sky130_fd_sc_hd__decap_8
XTAP_TAPCELL_ROW_73_1133 VGND VPWR sky130_fd_sc_hd__tapvpwrvgnd_1
X_6318_ _2180_ _2192_ VGND VGND VPWR VPWR _2195_ sky130_fd_sc_hd__xnor2_1
XFILLER_103_377 VGND VGND VPWR VPWR sky130_fd_sc_hd__fill_1
XFILLER_39_57 VGND VGND VPWR VPWR sky130_fd_sc_hd__decap_8
X_6249_ _2116_ _2118_ VGND VGND VPWR VPWR _2120_ sky130_fd_sc_hd__xnor2_1
XFILLER_76_217 VGND VGND VPWR VPWR sky130_fd_sc_hd__decap_8
XFILLER_45_604 VPWR VGND VPWR VGND sky130_ef_sc_hd__decap_12
XFILLER_55_12 VGND VGND VPWR VPWR sky130_fd_sc_hd__decap_3
XTAP_TAPCELL_ROW_4_298 VGND VPWR sky130_fd_sc_hd__tapvpwrvgnd_1
XFILLER_84_294 VGND VGND VPWR VPWR sky130_fd_sc_hd__decap_3
XFILLER_72_445 VGND VGND VPWR VPWR sky130_fd_sc_hd__fill_1
XFILLER_55_67 VGND VGND VPWR VPWR sky130_fd_sc_hd__decap_3
XFILLER_44_158 VGND VGND VPWR VPWR sky130_fd_sc_hd__decap_4
XFILLER_111_51 VGND VGND VPWR VPWR sky130_fd_sc_hd__decap_4
XTAP_TAPCELL_ROW_84_1262 VGND VPWR sky130_fd_sc_hd__tapvpwrvgnd_1
XFILLER_52_191 VGND VGND VPWR VPWR sky130_fd_sc_hd__decap_4
XFILLER_71_66 VGND VGND VPWR VPWR sky130_fd_sc_hd__fill_1
XFILLER_40_386 VGND VGND VPWR VPWR sky130_fd_sc_hd__decap_8
XTAP_TAPCELL_ROW_51_860 VGND VPWR sky130_fd_sc_hd__tapvpwrvgnd_1
XTAP_TAPCELL_ROW_95_1391 VGND VPWR sky130_fd_sc_hd__tapvpwrvgnd_1
XFILLER_4_265 VGND VGND VPWR VPWR sky130_fd_sc_hd__decap_8
XFILLER_20_81 VGND VGND VPWR VPWR sky130_fd_sc_hd__decap_3
XFILLER_96_41 VPWR VGND VPWR VGND sky130_ef_sc_hd__decap_12
XFILLER_95_515 VGND VGND VPWR VPWR sky130_fd_sc_hd__decap_4
XFILLER_96_85 VPWR VGND VPWR VGND sky130_ef_sc_hd__decap_12
XFILLER_67_228 VPWR VGND VPWR VGND sky130_ef_sc_hd__decap_12
XFILLER_48_453 VGND VGND VPWR VPWR sky130_fd_sc_hd__fill_2
XFILLER_75_261 VGND VGND VPWR VPWR sky130_fd_sc_hd__decap_8
XTAP_TAPCELL_ROW_59_960 VGND VPWR sky130_fd_sc_hd__tapvpwrvgnd_1
XFILLER_63_445 VGND VGND VPWR VPWR sky130_fd_sc_hd__decap_3
XFILLER_35_136 VPWR VGND VPWR VGND sky130_ef_sc_hd__decap_12
XFILLER_90_253 VPWR VGND VPWR VGND sky130_ef_sc_hd__decap_12
X_3950_ _3140_ _3133_ net119 _1528_ VGND VGND VPWR VPWR _alu_i0.Datapath_i.fu_alu_33673_33851.out1\[16\]
+ sky130_fd_sc_hd__a2bb2o_1
XFILLER_35_169 VPWR VGND VPWR VGND sky130_ef_sc_hd__decap_12
XFILLER_51_629 VPWR VGND VPWR VGND sky130_ef_sc_hd__decap_12
XFILLER_16_394 VGND VGND VPWR VPWR sky130_fd_sc_hd__fill_1
XFILLER_44_681 VGND VGND VPWR VPWR sky130_fd_sc_hd__decap_8
XFILLER_50_139 VGND VGND VPWR VPWR sky130_fd_sc_hd__fill_1
X_3881_ net220 net321 VGND VGND VPWR VPWR _3074_ sky130_fd_sc_hd__or2_1
XFILLER_84_3 VPWR VGND VPWR VGND sky130_ef_sc_hd__decap_12
XFILLER_31_386 VGND VGND VPWR VPWR sky130_fd_sc_hd__decap_6
X_5620_ _1396_ _1432_ _1433_ VGND VGND VPWR VPWR _1434_ sky130_fd_sc_hd__or3_2
X_5551_ net175 net172 net206 net199 VGND VGND VPWR VPWR _1358_ sky130_fd_sc_hd__nand4_2
X_4502_ _0252_ _0253_ _0266_ VGND VGND VPWR VPWR _0267_ sky130_fd_sc_hd__a21o_1
XFILLER_105_609 VGND VGND VPWR VPWR sky130_fd_sc_hd__decap_6
X_5482_ net361 net331 net325 net369 VGND VGND VPWR VPWR _1283_ sky130_fd_sc_hd__a22o_1
X_4433_ net286 net391 _0168_ _0167_ VGND VGND VPWR VPWR _0199_ sky130_fd_sc_hd__a31o_1
XFILLER_6_83 VGND VGND VPWR VPWR sky130_fd_sc_hd__fill_1
XFILLER_116_29 VPWR VGND VPWR VGND sky130_ef_sc_hd__decap_12
X_4364_ _0093_ _0101_ _0100_ VGND VGND VPWR VPWR _0132_ sky130_fd_sc_hd__o21bai_1
XFILLER_113_653 VPWR VGND VPWR VGND sky130_ef_sc_hd__decap_12
XFILLER_112_141 VPWR VGND VPWR VGND sky130_ef_sc_hd__decap_12
XFILLER_98_375 VPWR VGND VPWR VGND sky130_ef_sc_hd__decap_12
X_4295_ _0052_ _0064_ VGND VGND VPWR VPWR _0066_ sky130_fd_sc_hd__nor2_1
XFILLER_86_504 VGND VGND VPWR VPWR sky130_fd_sc_hd__decap_6
X_6103_ _1958_ _1959_ VGND VGND VPWR VPWR _1960_ sky130_fd_sc_hd__nand2_1
XFILLER_112_185 VGND VGND VPWR VPWR sky130_fd_sc_hd__decap_3
XFILLER_100_303 VGND VGND VPWR VPWR sky130_fd_sc_hd__decap_4
X_6034_ _1883_ VGND VGND VPWR VPWR _1884_ sky130_fd_sc_hd__inv_2
XFILLER_39_420 VGND VGND VPWR VPWR sky130_fd_sc_hd__fill_1
XFILLER_94_581 VGND VGND VPWR VPWR sky130_fd_sc_hd__decap_6
XFILLER_54_401 VGND VGND VPWR VPWR sky130_fd_sc_hd__decap_3
XTAP_TAPCELL_ROW_107_1538 VGND VPWR sky130_fd_sc_hd__tapvpwrvgnd_1
XTAP_TAPCELL_ROW_1_268 VGND VPWR sky130_fd_sc_hd__tapvpwrvgnd_1
XFILLER_14_309 VGND VGND VPWR VPWR sky130_fd_sc_hd__decap_3
XFILLER_25_15 VPWR VGND VPWR VGND sky130_ef_sc_hd__decap_12
XTAP_TAPCELL_ROW_37_698 VGND VPWR sky130_fd_sc_hd__tapvpwrvgnd_1
X_6867_ _2659_ _2664_ _2792_ net150 VGND VGND VPWR VPWR _2795_ sky130_fd_sc_hd__a31o_1
XFILLER_10_515 VGND VGND VPWR VPWR sky130_fd_sc_hd__fill_1
X_6798_ net258 net296 net292 net310 VGND VGND VPWR VPWR _2719_ sky130_fd_sc_hd__a22oi_1
X_5818_ _1478_ _1646_ _1647_ VGND VGND VPWR VPWR _1650_ sky130_fd_sc_hd__nand3_2
XFILLER_22_375 VGND VGND VPWR VPWR sky130_fd_sc_hd__decap_3
X_5749_ _1571_ _1573_ _1376_ _1378_ VGND VGND VPWR VPWR _1575_ sky130_fd_sc_hd__o211a_1
XFILLER_41_69 VGND VGND VPWR VPWR sky130_fd_sc_hd__decap_4
XFILLER_108_458 VGND VGND VPWR VPWR sky130_fd_sc_hd__decap_3
XTAP_TAPCELL_ROW_9_357 VGND VPWR sky130_fd_sc_hd__tapvpwrvgnd_1
XFILLER_89_364 VGND VGND VPWR VPWR sky130_fd_sc_hd__decap_3
XFILLER_89_353 VGND VGND VPWR VPWR sky130_fd_sc_hd__fill_2
XFILLER_92_529 VGND VGND VPWR VPWR sky130_fd_sc_hd__decap_3
XFILLER_17_125 VGND VGND VPWR VPWR sky130_fd_sc_hd__fill_2
XFILLER_18_637 VGND VGND VPWR VPWR sky130_fd_sc_hd__decap_6
XFILLER_72_264 VGND VGND VPWR VPWR sky130_fd_sc_hd__fill_1
XFILLER_72_253 VGND VGND VPWR VPWR sky130_fd_sc_hd__fill_2
XFILLER_17_169 VGND VGND VPWR VPWR sky130_fd_sc_hd__decap_3
XFILLER_33_607 VGND VGND VPWR VPWR sky130_fd_sc_hd__decap_8
XFILLER_82_54 VGND VGND VPWR VPWR sky130_fd_sc_hd__decap_8
XFILLER_72_286 VPWR VGND VPWR VGND sky130_ef_sc_hd__decap_12
XFILLER_26_681 VGND VGND VPWR VPWR sky130_fd_sc_hd__decap_8
XFILLER_33_629 VPWR VGND VPWR VGND sky130_ef_sc_hd__decap_12
XFILLER_13_331 VGND VGND VPWR VPWR sky130_fd_sc_hd__fill_1
XFILLER_13_342 VGND VGND VPWR VPWR sky130_fd_sc_hd__decap_4
XFILLER_15_70 VPWR VGND VPWR VGND sky130_ef_sc_hd__decap_12
XFILLER_40_161 VGND VGND VPWR VPWR sky130_fd_sc_hd__fill_1
XFILLER_41_673 VPWR VGND VPWR VGND sky130_ef_sc_hd__decap_12
XFILLER_9_357 VPWR VGND VPWR VGND sky130_ef_sc_hd__decap_12
XTAP_TAPCELL_ROW_97_1420 VGND VPWR sky130_fd_sc_hd__tapvpwrvgnd_1
XFILLER_5_541 VPWR VGND VPWR VGND sky130_ef_sc_hd__decap_12
XFILLER_5_585 VPWR VGND VPWR VGND sky130_ef_sc_hd__decap_12
Xoutput80 net80 VGND VGND VPWR VPWR return_port[12] sky130_fd_sc_hd__clkbuf_4
XFILLER_110_601 VPWR VGND VPWR VGND sky130_ef_sc_hd__decap_12
Xoutput91 net91 VGND VGND VPWR VPWR return_port[22] sky130_fd_sc_hd__clkbuf_4
XFILLER_110_645 VPWR VGND VPWR VGND sky130_ef_sc_hd__decap_12
X_4080_ _3259_ _3263_ _3264_ _2911_ net117 VGND VGND VPWR VPWR _alu_i0.Datapath_i.fu_alu_33673_33851.out1\[22\]
+ sky130_fd_sc_hd__a32o_1
XFILLER_110_689 VGND VGND VPWR VPWR sky130_fd_sc_hd__decap_3
XFILLER_95_367 VGND VGND VPWR VPWR sky130_fd_sc_hd__decap_8
XFILLER_36_401 VPWR VGND VPWR VGND sky130_ef_sc_hd__decap_12
XFILLER_76_581 VGND VGND VPWR VPWR sky130_fd_sc_hd__decap_6
X_4982_ _0737_ _0738_ _0739_ VGND VGND VPWR VPWR _0740_ sky130_fd_sc_hd__and3_1
X_6721_ _2458_ _2460_ _2633_ VGND VGND VPWR VPWR _2635_ sky130_fd_sc_hd__nand3_1
XTAP_TAPCELL_ROW_34_657 VGND VPWR sky130_fd_sc_hd__tapvpwrvgnd_1
X_3933_ net220 _0939_ _3097_ VGND VGND VPWR VPWR _3124_ sky130_fd_sc_hd__and3_1
XTAP_TAPCELL_ROW_102_1479 VGND VPWR sky130_fd_sc_hd__tapvpwrvgnd_1
XTAP_TAPCELL_ROW_62_999 VGND VPWR sky130_fd_sc_hd__tapvpwrvgnd_1
X_3864_ _3036_ _3056_ _3051_ VGND VGND VPWR VPWR _3058_ sky130_fd_sc_hd__a21oi_1
XFILLER_31_161 VGND VGND VPWR VPWR sky130_fd_sc_hd__decap_6
X_6652_ net185 _2558_ _2557_ VGND VGND VPWR VPWR _2559_ sky130_fd_sc_hd__a21bo_1
X_5603_ net375 net315 net307 net388 VGND VGND VPWR VPWR _1415_ sky130_fd_sc_hd__a22o_1
X_3795_ _1953_ _2990_ _2991_ _2987_ net127 VGND VGND VPWR VPWR _2992_ sky130_fd_sc_hd__a32o_1
X_6583_ _2313_ _2316_ _2483_ _2484_ VGND VGND VPWR VPWR _2485_ sky130_fd_sc_hd__a211oi_2
XFILLER_11_39 VPWR VGND VPWR VGND sky130_ef_sc_hd__decap_12
X_5534_ net463 _1338_ _1337_ VGND VGND VPWR VPWR _1339_ sky130_fd_sc_hd__a21bo_1
XFILLER_105_406 VPWR VGND VPWR VGND sky130_ef_sc_hd__decap_12
X_5465_ net420 net411 net299 net294 VGND VGND VPWR VPWR _1264_ sky130_fd_sc_hd__and4_1
X_4416_ _0145_ _0181_ VGND VGND VPWR VPWR _0183_ sky130_fd_sc_hd__or2_1
XFILLER_99_673 VPWR VGND VPWR VGND sky130_ef_sc_hd__decap_12
X_5396_ _1186_ _1187_ _1071_ _1074_ VGND VGND VPWR VPWR _1189_ sky130_fd_sc_hd__o211ai_2
Xfanout314 net318 VGND VGND VPWR VPWR net314 sky130_fd_sc_hd__buf_2
Xfanout303 net304 VGND VGND VPWR VPWR net303 sky130_fd_sc_hd__clkbuf_2
XFILLER_113_461 VPWR VGND VPWR VGND sky130_ef_sc_hd__decap_12
X_4347_ _0114_ _0115_ VGND VGND VPWR VPWR _0116_ sky130_fd_sc_hd__nand2b_1
XFILLER_59_526 VGND VGND VPWR VPWR sky130_fd_sc_hd__decap_6
Xfanout347 net348 VGND VGND VPWR VPWR net347 sky130_fd_sc_hd__clkbuf_4
XTAP_TAPCELL_ROW_6_327 VGND VPWR sky130_fd_sc_hd__tapvpwrvgnd_1
Xfanout336 net339 VGND VGND VPWR VPWR net336 sky130_fd_sc_hd__buf_2
Xfanout325 net326 VGND VGND VPWR VPWR net325 sky130_fd_sc_hd__buf_2
X_4278_ net473 net250 _1855_ VGND VGND VPWR VPWR _0050_ sky130_fd_sc_hd__and3_1
Xfanout358 net33 VGND VGND VPWR VPWR net358 sky130_fd_sc_hd__buf_2
Xfanout369 net31 VGND VGND VPWR VPWR net369 sky130_fd_sc_hd__clkbuf_4
X_6017_ net421 net264 net257 net452 VGND VGND VPWR VPWR _1866_ sky130_fd_sc_hd__a22oi_1
XTAP_TAPCELL_ROW_68_1065 VGND VPWR sky130_fd_sc_hd__tapvpwrvgnd_1
XFILLER_27_456 VGND VGND VPWR VPWR sky130_fd_sc_hd__decap_4
XFILLER_14_128 VGND VGND VPWR VPWR sky130_fd_sc_hd__fill_1
XFILLER_15_629 VPWR VGND VPWR VGND sky130_ef_sc_hd__decap_12
XFILLER_27_489 VPWR VGND VPWR VGND sky130_ef_sc_hd__decap_12
XTAP_TAPCELL_ROW_81_1221 VGND VPWR sky130_fd_sc_hd__tapvpwrvgnd_1
XFILLER_23_673 VPWR VGND VPWR VGND sky130_ef_sc_hd__decap_12
XFILLER_10_334 VPWR VGND VPWR VGND sky130_ef_sc_hd__decap_12
XFILLER_22_183 VPWR VGND VPWR VGND sky130_ef_sc_hd__decap_12
XFILLER_6_305 VGND VGND VPWR VPWR sky130_fd_sc_hd__decap_3
XTAP_TAPCELL_ROW_79_1194 VGND VPWR sky130_fd_sc_hd__tapvpwrvgnd_1
XFILLER_2_533 VPWR VGND VPWR VGND sky130_ef_sc_hd__decap_12
XTAP_TAPCELL_ROW_92_1361 VGND VPWR sky130_fd_sc_hd__tapvpwrvgnd_1
XTAP_TAPCELL_ROW_92_1350 VGND VPWR sky130_fd_sc_hd__tapvpwrvgnd_1
XFILLER_104_472 VGND VGND VPWR VPWR sky130_fd_sc_hd__decap_4
XFILLER_89_150 VGND VGND VPWR VPWR sky130_fd_sc_hd__decap_4
XFILLER_77_54 VGND VGND VPWR VPWR sky130_fd_sc_hd__fill_2
XFILLER_77_65 VGND VGND VPWR VPWR sky130_fd_sc_hd__decap_8
XFILLER_65_529 VPWR VGND VPWR VGND sky130_ef_sc_hd__decap_12
XFILLER_93_42 VPWR VGND VPWR VGND sky130_ef_sc_hd__decap_12
XFILLER_45_253 VGND VGND VPWR VPWR sky130_fd_sc_hd__decap_8
XFILLER_9_110 VGND VGND VPWR VPWR sky130_fd_sc_hd__fill_2
XTAP_TAPCELL_ROW_31_627 VGND VPWR sky130_fd_sc_hd__tapvpwrvgnd_1
X_3580_ net280 _2652_ _2663_ net349 VGND VGND VPWR VPWR _2673_ sky130_fd_sc_hd__o22a_1
XTAP_TAPCELL_ROW_11_384 VGND VPWR sky130_fd_sc_hd__tapvpwrvgnd_1
X_5250_ _0921_ _0923_ _1028_ _1029_ VGND VGND VPWR VPWR _1030_ sky130_fd_sc_hd__a211o_1
XFILLER_114_269 VPWR VGND VPWR VGND sky130_ef_sc_hd__decap_12
XFILLER_87_109 VGND VGND VPWR VPWR sky130_fd_sc_hd__decap_3
X_4201_ _3371_ _3378_ _3379_ VGND VGND VPWR VPWR _3380_ sky130_fd_sc_hd__a21oi_1
XFILLER_47_3 VPWR VGND VPWR VGND sky130_ef_sc_hd__decap_12
X_5181_ _0953_ _0954_ VGND VGND VPWR VPWR _0955_ sky130_fd_sc_hd__and2b_1
XFILLER_96_643 VGND VGND VPWR VPWR sky130_fd_sc_hd__fill_1
XFILLER_3_51 VGND VGND VPWR VPWR sky130_fd_sc_hd__decap_4
X_4132_ _3312_ _3313_ VGND VGND VPWR VPWR _3314_ sky130_fd_sc_hd__nand2_2
XTAP_TAPCELL_ROW_39_716 VGND VPWR sky130_fd_sc_hd__tapvpwrvgnd_1
X_4063_ _3245_ _3246_ VGND VGND VPWR VPWR _3248_ sky130_fd_sc_hd__nand2_1
XFILLER_95_197 VGND VGND VPWR VPWR sky130_fd_sc_hd__decap_8
XFILLER_83_337 VGND VGND VPWR VPWR sky130_fd_sc_hd__decap_8
XFILLER_36_286 VGND VGND VPWR VPWR sky130_fd_sc_hd__fill_2
X_4965_ _0719_ _0720_ _0721_ VGND VGND VPWR VPWR _0723_ sky130_fd_sc_hd__a21o_1
XTAP_TAPCELL_ROW_19_484 VGND VPWR sky130_fd_sc_hd__tapvpwrvgnd_1
XFILLER_51_223 VGND VGND VPWR VPWR sky130_fd_sc_hd__fill_1
X_3916_ _2818_ _2823_ _2829_ _2820_ net232 net159 VGND VGND VPWR VPWR _3108_ sky130_fd_sc_hd__mux4_1
X_6704_ _2614_ _2615_ VGND VGND VPWR VPWR _2616_ sky130_fd_sc_hd__nand2_1
X_4896_ _0651_ _0652_ _0653_ VGND VGND VPWR VPWR _0655_ sky130_fd_sc_hd__a21oi_1
XFILLER_20_643 VGND VGND VPWR VPWR sky130_fd_sc_hd__fill_1
XFILLER_32_492 VPWR VGND VPWR VGND sky130_ef_sc_hd__decap_12
X_3847_ _2956_ _3041_ net159 VGND VGND VPWR VPWR _3042_ sky130_fd_sc_hd__mux2_1
X_6635_ _2532_ _2539_ VGND VGND VPWR VPWR _2540_ sky130_fd_sc_hd__and2_1
XFILLER_22_27 VGND VGND VPWR VPWR sky130_fd_sc_hd__fill_1
X_3778_ net239 _1583_ _2456_ VGND VGND VPWR VPWR _2976_ sky130_fd_sc_hd__and3_1
X_6566_ _2290_ _2293_ _2464_ VGND VGND VPWR VPWR _2466_ sky130_fd_sc_hd__and3_1
XTAP_TAPCELL_ROW_115_1626 VGND VPWR sky130_fd_sc_hd__tapvpwrvgnd_1
X_5517_ _1193_ net111 _1318_ _1319_ VGND VGND VPWR VPWR _1322_ sky130_fd_sc_hd__o211ai_1
XTAP_TAPCELL_ROW_115_1637 VGND VPWR sky130_fd_sc_hd__tapvpwrvgnd_1
X_6497_ net166 net329 net323 net171 VGND VGND VPWR VPWR _2391_ sky130_fd_sc_hd__a22oi_1
X_5448_ _1126_ _1129_ _1243_ _1245_ VGND VGND VPWR VPWR _1246_ sky130_fd_sc_hd__a211oi_2
Xfanout122 _1561_ VGND VGND VPWR VPWR net122 sky130_fd_sc_hd__clkbuf_4
X_5379_ _1064_ _1065_ _1062_ VGND VGND VPWR VPWR _1171_ sky130_fd_sc_hd__o21ai_1
XFILLER_101_420 VGND VGND VPWR VPWR sky130_fd_sc_hd__decap_4
XFILLER_99_492 VPWR VGND VPWR VGND sky130_ef_sc_hd__decap_12
Xfanout155 net156 VGND VGND VPWR VPWR net155 sky130_fd_sc_hd__clkbuf_4
Xfanout144 net145 VGND VGND VPWR VPWR net144 sky130_fd_sc_hd__clkbuf_4
Xfanout133 _1190_ VGND VGND VPWR VPWR net133 sky130_fd_sc_hd__clkbuf_4
XFILLER_87_665 VGND VGND VPWR VPWR sky130_fd_sc_hd__decap_6
Xfanout188 net64 VGND VGND VPWR VPWR net188 sky130_fd_sc_hd__buf_2
Xfanout177 net178 VGND VGND VPWR VPWR net177 sky130_fd_sc_hd__clkbuf_4
Xfanout166 net167 VGND VGND VPWR VPWR net166 sky130_fd_sc_hd__buf_2
XFILLER_47_46 VGND VGND VPWR VPWR sky130_fd_sc_hd__decap_8
Xfanout199 net200 VGND VGND VPWR VPWR net199 sky130_fd_sc_hd__clkbuf_4
XPHY_EDGE_ROW_29_Right_29 VGND VGND VPWR VPWR sky130_fd_sc_hd__decap_3
XFILLER_47_57 VPWR VGND VPWR VGND sky130_ef_sc_hd__decap_12
XFILLER_74_359 VGND VGND VPWR VPWR sky130_fd_sc_hd__decap_4
XFILLER_82_381 VPWR VGND VPWR VGND sky130_ef_sc_hd__decap_12
XFILLER_55_595 VPWR VGND VPWR VGND sky130_ef_sc_hd__decap_12
XFILLER_70_543 VGND VGND VPWR VPWR sky130_fd_sc_hd__fill_2
XFILLER_63_67 VGND VGND VPWR VPWR sky130_fd_sc_hd__fill_1
XFILLER_42_223 VGND VGND VPWR VPWR sky130_fd_sc_hd__decap_4
XFILLER_8_29 VPWR VGND VPWR VGND sky130_ef_sc_hd__decap_12
XFILLER_11_665 VGND VGND VPWR VPWR sky130_fd_sc_hd__decap_6
XPHY_EDGE_ROW_38_Right_38 VGND VGND VPWR VPWR sky130_fd_sc_hd__decap_3
XFILLER_10_175 VPWR VGND VPWR VGND sky130_ef_sc_hd__decap_12
XFILLER_6_113 VGND VGND VPWR VPWR sky130_fd_sc_hd__fill_1
XFILLER_109_597 VPWR VGND VPWR VGND sky130_ef_sc_hd__decap_12
XFILLER_12_82 VGND VGND VPWR VPWR sky130_fd_sc_hd__fill_2
XFILLER_97_429 VPWR VGND VPWR VGND sky130_ef_sc_hd__decap_12
XFILLER_78_643 VGND VGND VPWR VPWR sky130_fd_sc_hd__fill_1
XFILLER_93_613 VGND VGND VPWR VPWR sky130_fd_sc_hd__decap_3
XFILLER_38_529 VGND VGND VPWR VPWR sky130_fd_sc_hd__decap_3
XPHY_EDGE_ROW_47_Right_47 VGND VGND VPWR VPWR sky130_fd_sc_hd__decap_3
XFILLER_92_101 VGND VGND VPWR VPWR sky130_fd_sc_hd__decap_3
XFILLER_65_337 VGND VGND VPWR VPWR sky130_fd_sc_hd__decap_3
XFILLER_65_326 VGND VGND VPWR VPWR sky130_fd_sc_hd__decap_8
XFILLER_73_370 VGND VGND VPWR VPWR sky130_fd_sc_hd__decap_8
XFILLER_18_253 VPWR VGND VPWR VGND sky130_ef_sc_hd__decap_12
XFILLER_18_297 VGND VGND VPWR VPWR sky130_fd_sc_hd__decap_8
XFILLER_33_223 VGND VGND VPWR VPWR sky130_fd_sc_hd__fill_1
XTAP_TAPCELL_ROW_16_443 VGND VPWR sky130_fd_sc_hd__tapvpwrvgnd_1
XFILLER_33_256 VGND VGND VPWR VPWR sky130_fd_sc_hd__decap_8
XTAP_TAPCELL_ROW_44_774 VGND VPWR sky130_fd_sc_hd__tapvpwrvgnd_1
X_4750_ net372 net216 _0508_ _0509_ VGND VGND VPWR VPWR _0511_ sky130_fd_sc_hd__nand4_1
XPHY_EDGE_ROW_56_Right_56 VGND VGND VPWR VPWR sky130_fd_sc_hd__decap_3
XTAP_TAPCELL_ROW_44_785 VGND VPWR sky130_fd_sc_hd__tapvpwrvgnd_1
X_4681_ _0440_ _0441_ _0437_ VGND VGND VPWR VPWR _0443_ sky130_fd_sc_hd__a21o_1
X_3701_ net398 _0917_ _2845_ _2847_ _2873_ VGND VGND VPWR VPWR _2902_ sky130_fd_sc_hd__a221o_1
X_3632_ net163 net416 _2401_ VGND VGND VPWR VPWR _2836_ sky130_fd_sc_hd__a21bo_1
X_6420_ _2147_ _2149_ _2305_ _2306_ VGND VGND VPWR VPWR _2307_ sky130_fd_sc_hd__o211ai_2
X_6351_ net171 net329 net323 net174 VGND VGND VPWR VPWR _2231_ sky130_fd_sc_hd__a22oi_1
X_5302_ _0932_ _0934_ _1085_ _1086_ VGND VGND VPWR VPWR _1087_ sky130_fd_sc_hd__a211oi_2
X_3563_ _2008_ _2478_ VGND VGND VPWR VPWR _alu_i0.Datapath_i.fu_alu_33673_33851.out1\[1\]
+ sky130_fd_sc_hd__or2_1
X_3494_ net354 net414 VGND VGND VPWR VPWR _1735_ sky130_fd_sc_hd__nand2_1
X_6282_ _2152_ _2154_ _1987_ _1990_ VGND VGND VPWR VPWR _2156_ sky130_fd_sc_hd__o211ai_2
XFILLER_88_418 VGND VGND VPWR VPWR sky130_fd_sc_hd__fill_2
X_5233_ _0998_ _1009_ VGND VGND VPWR VPWR _1011_ sky130_fd_sc_hd__xnor2_1
XPHY_EDGE_ROW_65_Right_65 VGND VGND VPWR VPWR sky130_fd_sc_hd__decap_3
X_5164_ net453 net303 net299 net469 VGND VGND VPWR VPWR _0936_ sky130_fd_sc_hd__a22oi_1
XFILLER_110_250 VGND VGND VPWR VPWR sky130_fd_sc_hd__fill_2
XTAP_TAPCELL_ROW_110_1567 VGND VPWR sky130_fd_sc_hd__tapvpwrvgnd_1
XFILLER_96_451 VPWR VGND VPWR VGND sky130_ef_sc_hd__decap_12
XFILLER_69_665 VGND VGND VPWR VPWR sky130_fd_sc_hd__decap_6
X_4115_ _3229_ _3293_ _3296_ VGND VGND VPWR VPWR _3298_ sky130_fd_sc_hd__a21oi_1
X_5095_ _0858_ _0859_ _0848_ VGND VGND VPWR VPWR _0861_ sky130_fd_sc_hd__a21oi_2
XFILLER_68_197 VGND VGND VPWR VPWR sky130_fd_sc_hd__decap_8
XFILLER_84_657 VPWR VGND VPWR VGND sky130_ef_sc_hd__decap_12
XFILLER_17_27 VPWR VGND VPWR VGND sky130_ef_sc_hd__decap_12
X_4046_ net126 _3230_ _3231_ _3226_ VGND VGND VPWR VPWR _3232_ sky130_fd_sc_hd__a31o_1
XFILLER_83_189 VGND VGND VPWR VPWR sky130_fd_sc_hd__fill_1
XFILLER_83_167 VGND VGND VPWR VPWR sky130_fd_sc_hd__fill_1
XFILLER_71_329 VGND VGND VPWR VPWR sky130_fd_sc_hd__decap_6
XTAP_TAPCELL_ROW_65_1035 VGND VPWR sky130_fd_sc_hd__tapvpwrvgnd_1
XPHY_EDGE_ROW_74_Right_74 VGND VGND VPWR VPWR sky130_fd_sc_hd__decap_3
XFILLER_12_418 VGND VGND VPWR VPWR sky130_fd_sc_hd__fill_2
XFILLER_33_15 VPWR VGND VPWR VGND sky130_ef_sc_hd__decap_12
X_5997_ _1840_ _1841_ _1694_ _1698_ VGND VGND VPWR VPWR _1845_ sky130_fd_sc_hd__o211ai_2
X_4948_ _0704_ _0705_ VGND VGND VPWR VPWR _0706_ sky130_fd_sc_hd__and2b_1
XFILLER_12_429 VGND VGND VPWR VPWR sky130_fd_sc_hd__fill_1
X_4879_ _0636_ _0637_ VGND VGND VPWR VPWR _0638_ sky130_fd_sc_hd__and2b_1
X_6618_ _2507_ _2521_ VGND VGND VPWR VPWR _2522_ sky130_fd_sc_hd__or2_1
XFILLER_106_523 VGND VGND VPWR VPWR sky130_fd_sc_hd__decap_8
X_6549_ _1462_ _2446_ VGND VGND VPWR VPWR _2448_ sky130_fd_sc_hd__nor2_1
XFILLER_106_545 VPWR VGND VPWR VGND sky130_ef_sc_hd__decap_12
XPHY_EDGE_ROW_83_Right_83 VGND VGND VPWR VPWR sky130_fd_sc_hd__decap_3
XTAP_TAPCELL_ROW_76_1164 VGND VPWR sky130_fd_sc_hd__tapvpwrvgnd_1
XFILLER_3_149 VGND VGND VPWR VPWR sky130_fd_sc_hd__fill_1
XPHY_EDGE_ROW_18_Left_135 VGND VGND VPWR VPWR sky130_fd_sc_hd__decap_3
XFILLER_106_589 VPWR VGND VPWR VGND sky130_ef_sc_hd__decap_12
XFILLER_79_429 VGND VGND VPWR VPWR sky130_fd_sc_hd__decap_8
XFILLER_101_250 VGND VGND VPWR VPWR sky130_fd_sc_hd__fill_1
XFILLER_87_473 VPWR VGND VPWR VGND sky130_ef_sc_hd__decap_12
XFILLER_59_164 VGND VGND VPWR VPWR sky130_fd_sc_hd__decap_4
XFILLER_59_131 VGND VGND VPWR VPWR sky130_fd_sc_hd__decap_4
XFILLER_47_304 VPWR VGND VPWR VGND sky130_ef_sc_hd__decap_12
XFILLER_74_123 VPWR VGND VPWR VGND sky130_ef_sc_hd__decap_12
XFILLER_74_112 VGND VGND VPWR VPWR sky130_fd_sc_hd__fill_2
XFILLER_47_337 VGND VGND VPWR VPWR sky130_fd_sc_hd__decap_8
XFILLER_74_55 VGND VGND VPWR VPWR sky130_fd_sc_hd__fill_1
XFILLER_55_370 VPWR VGND VPWR VGND sky130_ef_sc_hd__decap_12
XPHY_EDGE_ROW_27_Left_144 VGND VGND VPWR VPWR sky130_fd_sc_hd__decap_3
XPHY_EDGE_ROW_92_Right_92 VGND VGND VPWR VPWR sky130_fd_sc_hd__decap_3
XTAP_TAPCELL_ROW_87_1293 VGND VPWR sky130_fd_sc_hd__tapvpwrvgnd_1
XFILLER_15_223 VGND VGND VPWR VPWR sky130_fd_sc_hd__fill_1
XFILLER_43_521 VGND VGND VPWR VPWR sky130_fd_sc_hd__fill_1
XFILLER_43_565 VGND VGND VPWR VPWR sky130_fd_sc_hd__fill_1
XTAP_TAPCELL_ROW_13_402 VGND VPWR sky130_fd_sc_hd__tapvpwrvgnd_1
XTAP_TAPCELL_ROW_13_413 VGND VPWR sky130_fd_sc_hd__tapvpwrvgnd_1
XFILLER_30_215 VGND VGND VPWR VPWR sky130_fd_sc_hd__fill_1
XFILLER_43_598 VPWR VGND VPWR VGND sky130_ef_sc_hd__decap_12
XTAP_TAPCELL_ROW_41_744 VGND VPWR sky130_fd_sc_hd__tapvpwrvgnd_1
XFILLER_116_309 VGND VGND VPWR VPWR sky130_fd_sc_hd__decap_4
XPHY_EDGE_ROW_36_Left_153 VGND VGND VPWR VPWR sky130_fd_sc_hd__decap_3
XFILLER_109_361 VPWR VGND VPWR VGND sky130_ef_sc_hd__decap_12
XFILLER_99_63 VGND VGND VPWR VPWR sky130_fd_sc_hd__decap_4
XFILLER_97_237 VGND VGND VPWR VPWR sky130_fd_sc_hd__decap_4
XFILLER_2_160 VGND VGND VPWR VPWR sky130_fd_sc_hd__decap_6
XFILLER_78_451 VPWR VGND VPWR VGND sky130_ef_sc_hd__decap_12
XFILLER_66_613 VPWR VGND VPWR VGND sky130_ef_sc_hd__decap_12
XFILLER_66_657 VPWR VGND VPWR VGND sky130_ef_sc_hd__decap_12
XFILLER_65_145 VGND VGND VPWR VPWR sky130_fd_sc_hd__fill_2
XFILLER_19_551 VGND VGND VPWR VPWR sky130_fd_sc_hd__fill_1
XPHY_EDGE_ROW_45_Left_162 VGND VGND VPWR VPWR sky130_fd_sc_hd__decap_3
XTAP_TAPCELL_ROW_49_844 VGND VPWR sky130_fd_sc_hd__tapvpwrvgnd_1
XFILLER_93_498 VGND VGND VPWR VPWR sky130_fd_sc_hd__decap_6
XFILLER_80_104 VPWR VGND VPWR VGND sky130_ef_sc_hd__decap_12
XFILLER_0_41 VPWR VGND VPWR VGND sky130_ef_sc_hd__decap_12
X_5920_ _1759_ _1760_ VGND VGND VPWR VPWR _1761_ sky130_fd_sc_hd__and2b_1
X_5851_ _1676_ _1684_ _1685_ VGND VGND VPWR VPWR _1686_ sky130_fd_sc_hd__nand3_2
XPHY_EDGE_ROW_100_Right_100 VGND VGND VPWR VPWR sky130_fd_sc_hd__decap_3
X_4802_ net290 net311 _0499_ _0497_ VGND VGND VPWR VPWR _0562_ sky130_fd_sc_hd__a31o_1
XFILLER_61_373 VPWR VGND VPWR VGND sky130_ef_sc_hd__decap_12
X_5782_ _1589_ _1609_ VGND VGND VPWR VPWR _1610_ sky130_fd_sc_hd__and2_1
X_4733_ _0492_ _0493_ _0491_ VGND VGND VPWR VPWR _0494_ sky130_fd_sc_hd__a21o_1
XFILLER_21_259 VPWR VGND VPWR VGND sky130_ef_sc_hd__decap_12
XPHY_EDGE_ROW_54_Left_171 VGND VGND VPWR VPWR sky130_fd_sc_hd__decap_3
X_4664_ _0356_ _0358_ _0357_ VGND VGND VPWR VPWR _0426_ sky130_fd_sc_hd__a21bo_1
X_6403_ net16 net213 VGND VGND VPWR VPWR _2288_ sky130_fd_sc_hd__nand2_1
X_4595_ net229 net378 net371 net242 VGND VGND VPWR VPWR _0358_ sky130_fd_sc_hd__a22o_1
X_3615_ net277 _2106_ VGND VGND VPWR VPWR _2819_ sky130_fd_sc_hd__nor2_1
X_3546_ net363 net431 net385 net312 net354 net288 VGND VGND VPWR VPWR _2303_ sky130_fd_sc_hd__mux4_1
X_6334_ _2202_ _2211_ VGND VGND VPWR VPWR _2212_ sky130_fd_sc_hd__and2_1
XFILLER_1_609 VGND VGND VPWR VPWR sky130_fd_sc_hd__decap_6
X_6265_ _2131_ _2135_ _2136_ VGND VGND VPWR VPWR _2137_ sky130_fd_sc_hd__nand3_2
XFILLER_103_548 VPWR VGND VPWR VGND sky130_ef_sc_hd__decap_12
X_5216_ _0788_ _0790_ _0884_ _0886_ VGND VGND VPWR VPWR _0993_ sky130_fd_sc_hd__or4b_1
X_3477_ _0776_ net179 _1048_ VGND VGND VPWR VPWR _1550_ sky130_fd_sc_hd__or3_4
X_6196_ _2058_ _2059_ _2037_ VGND VGND VPWR VPWR _2061_ sky130_fd_sc_hd__a21o_1
XFILLER_84_421 VGND VGND VPWR VPWR sky130_fd_sc_hd__decap_8
X_5147_ _0915_ _0916_ _0909_ VGND VGND VPWR VPWR _0918_ sky130_fd_sc_hd__a21o_1
XFILLER_69_484 VGND VGND VPWR VPWR sky130_fd_sc_hd__decap_3
XFILLER_69_473 VGND VGND VPWR VPWR sky130_fd_sc_hd__decap_3
XPHY_EDGE_ROW_63_Left_180 VGND VGND VPWR VPWR sky130_fd_sc_hd__decap_3
XFILLER_57_624 VPWR VGND VPWR VGND sky130_ef_sc_hd__decap_12
XFILLER_56_112 VGND VGND VPWR VPWR sky130_fd_sc_hd__fill_1
XFILLER_28_15 VPWR VGND VPWR VGND sky130_ef_sc_hd__decap_12
XFILLER_29_326 VGND VGND VPWR VPWR sky130_fd_sc_hd__decap_8
XFILLER_29_337 VGND VGND VPWR VPWR sky130_fd_sc_hd__decap_8
X_5078_ _0832_ _0842_ VGND VGND VPWR VPWR _0843_ sky130_fd_sc_hd__xnor2_1
XFILLER_72_605 VGND VGND VPWR VPWR sky130_fd_sc_hd__fill_1
X_4029_ net123 _3214_ _3215_ VGND VGND VPWR VPWR _3216_ sky130_fd_sc_hd__and3_1
XFILLER_71_159 VGND VGND VPWR VPWR sky130_fd_sc_hd__fill_1
XFILLER_52_362 VGND VGND VPWR VPWR sky130_fd_sc_hd__fill_2
XFILLER_100_53 VPWR VGND VPWR VGND sky130_ef_sc_hd__decap_12
XFILLER_100_97 VPWR VGND VPWR VGND sky130_ef_sc_hd__decap_12
XFILLER_20_270 VGND VGND VPWR VPWR sky130_fd_sc_hd__decap_4
XFILLER_114_3 VPWR VGND VPWR VGND sky130_ef_sc_hd__decap_12
XFILLER_109_51 VGND VGND VPWR VPWR sky130_fd_sc_hd__decap_4
XFILLER_69_44 VPWR VGND VPWR VGND sky130_ef_sc_hd__decap_12
XFILLER_4_469 VGND VGND VPWR VPWR sky130_fd_sc_hd__decap_6
XFILLER_69_77 VPWR VGND VPWR VGND sky130_ef_sc_hd__decap_12
XTAP_TAPCELL_ROW_89_1322 VGND VPWR sky130_fd_sc_hd__tapvpwrvgnd_1
XFILLER_87_281 VPWR VGND VPWR VGND sky130_ef_sc_hd__decap_12
XFILLER_48_624 VPWR VGND VPWR VGND sky130_ef_sc_hd__decap_12
XFILLER_75_432 VPWR VGND VPWR VGND sky130_ef_sc_hd__decap_12
XFILLER_48_657 VPWR VGND VPWR VGND sky130_ef_sc_hd__decap_12
XFILLER_90_413 VGND VGND VPWR VPWR sky130_fd_sc_hd__decap_6
XTAP_TAPCELL_ROW_46_803 VGND VPWR sky130_fd_sc_hd__tapvpwrvgnd_1
XFILLER_16_554 VGND VGND VPWR VPWR sky130_fd_sc_hd__fill_1
XFILLER_16_565 VGND VGND VPWR VPWR sky130_fd_sc_hd__decap_3
XTAP_TAPCELL_ROW_26_560 VGND VPWR sky130_fd_sc_hd__tapvpwrvgnd_1
XFILLER_11_281 VGND VGND VPWR VPWR sky130_fd_sc_hd__decap_8
X_4380_ _0112_ _0146_ VGND VGND VPWR VPWR _0148_ sky130_fd_sc_hd__nand2_1
XFILLER_98_513 VPWR VGND VPWR VGND sky130_ef_sc_hd__decap_12
XFILLER_98_557 VPWR VGND VPWR VGND sky130_ef_sc_hd__decap_12
XFILLER_112_345 VGND VGND VPWR VPWR sky130_fd_sc_hd__fill_1
X_6050_ _1899_ _1900_ _1754_ VGND VGND VPWR VPWR _1902_ sky130_fd_sc_hd__o21a_1
XFILLER_112_389 VPWR VGND VPWR VGND sky130_ef_sc_hd__decap_12
X_5001_ _0748_ _0757_ _0758_ VGND VGND VPWR VPWR _0759_ sky130_fd_sc_hd__and3_1
XFILLER_78_292 VGND VGND VPWR VPWR sky130_fd_sc_hd__decap_3
X_6883_ net181 _alu_i0.Datapath_i.fu_alu_33673_33851.out1\[9\] VGND VGND VPWR VPWR
+ _alu_i0.Datapath_i.reg_0.reg_out1\[9\] sky130_fd_sc_hd__dfxtp_1
XFILLER_81_468 VGND VGND VPWR VPWR sky130_fd_sc_hd__decap_8
X_5903_ _1741_ _1740_ VGND VGND VPWR VPWR _1742_ sky130_fd_sc_hd__and2b_1
XFILLER_34_340 VPWR VGND VPWR VGND sky130_ef_sc_hd__decap_12
X_5834_ net283 net441 VGND VGND VPWR VPWR _1667_ sky130_fd_sc_hd__and2_1
X_5765_ net411 net273 net270 net420 VGND VGND VPWR VPWR _1591_ sky130_fd_sc_hd__a22o_1
X_4716_ net409 net190 net345 net417 VGND VGND VPWR VPWR _0477_ sky130_fd_sc_hd__a22o_1
X_5696_ _1499_ _1512_ _1514_ VGND VGND VPWR VPWR _1516_ sky130_fd_sc_hd__or3_2
X_4647_ net424 net417 net189 net344 VGND VGND VPWR VPWR _0409_ sky130_fd_sc_hd__and4_1
XFILLER_30_27 VGND VGND VPWR VPWR sky130_fd_sc_hd__fill_1
XFILLER_116_673 VPWR VGND VPWR VGND sky130_ef_sc_hd__decap_12
X_4578_ _0283_ _0284_ _0285_ VGND VGND VPWR VPWR _0342_ sky130_fd_sc_hd__a21oi_2
XTAP_TAPCELL_ROW_73_1123 VGND VPWR sky130_fd_sc_hd__tapvpwrvgnd_1
X_6317_ _2180_ _2192_ VGND VGND VPWR VPWR _2194_ sky130_fd_sc_hd__and2_1
XFILLER_103_301 VPWR VGND VPWR VGND sky130_ef_sc_hd__decap_12
X_3529_ _2084_ _2106_ net278 VGND VGND VPWR VPWR _2117_ sky130_fd_sc_hd__mux2_1
XFILLER_103_345 VGND VGND VPWR VPWR sky130_fd_sc_hd__decap_6
X_6248_ _2118_ _2116_ VGND VGND VPWR VPWR _2119_ sky130_fd_sc_hd__nand2b_1
X_6179_ _2041_ _2042_ VGND VGND VPWR VPWR _2043_ sky130_fd_sc_hd__nor2_1
XFILLER_69_281 VPWR VGND VPWR VGND sky130_ef_sc_hd__decap_12
XFILLER_84_251 VGND VGND VPWR VPWR sky130_fd_sc_hd__fill_1
XFILLER_57_487 VPWR VGND VPWR VGND sky130_ef_sc_hd__decap_12
XTAP_TAPCELL_ROW_4_299 VGND VPWR sky130_fd_sc_hd__tapvpwrvgnd_1
XFILLER_29_156 VGND VGND VPWR VPWR sky130_fd_sc_hd__fill_2
XFILLER_29_167 VGND VGND VPWR VPWR sky130_fd_sc_hd__fill_1
XFILLER_55_57 VGND VGND VPWR VPWR sky130_fd_sc_hd__decap_6
XFILLER_72_468 VGND VGND VPWR VPWR sky130_fd_sc_hd__fill_1
XFILLER_60_608 VGND VGND VPWR VPWR sky130_fd_sc_hd__fill_2
XTAP_TAPCELL_ROW_84_1263 VGND VPWR sky130_fd_sc_hd__tapvpwrvgnd_1
XFILLER_53_671 VGND VGND VPWR VPWR sky130_fd_sc_hd__fill_1
XFILLER_13_524 VGND VGND VPWR VPWR sky130_fd_sc_hd__fill_2
XFILLER_71_45 VGND VGND VPWR VPWR sky130_fd_sc_hd__fill_1
XTAP_TAPCELL_ROW_23_530 VGND VPWR sky130_fd_sc_hd__tapvpwrvgnd_1
XFILLER_40_365 VGND VGND VPWR VPWR sky130_fd_sc_hd__decap_8
XTAP_TAPCELL_ROW_51_861 VGND VPWR sky130_fd_sc_hd__tapvpwrvgnd_1
XFILLER_4_233 VPWR VGND VPWR VGND sky130_ef_sc_hd__decap_12
XFILLER_107_673 VPWR VGND VPWR VGND sky130_ef_sc_hd__decap_12
XTAP_TAPCELL_ROW_95_1392 VGND VPWR sky130_fd_sc_hd__tapvpwrvgnd_1
XFILLER_20_71 VGND VGND VPWR VPWR sky130_fd_sc_hd__fill_1
XFILLER_20_93 VGND VGND VPWR VPWR sky130_fd_sc_hd__fill_2
XFILLER_96_53 VGND VGND VPWR VPWR sky130_fd_sc_hd__decap_4
XFILLER_95_527 VGND VGND VPWR VPWR sky130_fd_sc_hd__decap_3
XFILLER_0_461 VPWR VGND VPWR VGND sky130_ef_sc_hd__decap_12
XFILLER_96_97 VGND VGND VPWR VPWR sky130_fd_sc_hd__decap_8
XFILLER_48_421 VGND VGND VPWR VPWR sky130_fd_sc_hd__decap_6
XTAP_TAPCELL_ROW_59_961 VGND VPWR sky130_fd_sc_hd__tapvpwrvgnd_1
XFILLER_48_465 VGND VGND VPWR VPWR sky130_fd_sc_hd__decap_4
XFILLER_48_487 VGND VGND VPWR VPWR sky130_fd_sc_hd__decap_6
XFILLER_90_265 VPWR VGND VPWR VGND sky130_ef_sc_hd__decap_12
XFILLER_90_243 VGND VGND VPWR VPWR sky130_fd_sc_hd__decap_8
XFILLER_35_148 VPWR VGND VPWR VGND sky130_ef_sc_hd__decap_12
X_3880_ net142 _3072_ net135 VGND VGND VPWR VPWR _3073_ sky130_fd_sc_hd__o21ai_1
XFILLER_43_181 VGND VGND VPWR VPWR sky130_fd_sc_hd__fill_1
XFILLER_77_3 VPWR VGND VPWR VGND sky130_ef_sc_hd__decap_12
X_5550_ net172 net206 net199 net175 VGND VGND VPWR VPWR _1357_ sky130_fd_sc_hd__a22o_1
X_4501_ _0196_ _0264_ VGND VGND VPWR VPWR _0266_ sky130_fd_sc_hd__xor2_1
X_5481_ net369 net360 net331 net325 VGND VGND VPWR VPWR _1282_ sky130_fd_sc_hd__nand4_1
X_4432_ _0196_ _0197_ VGND VGND VPWR VPWR _0198_ sky130_fd_sc_hd__nor2_1
XFILLER_104_109 VGND VGND VPWR VPWR sky130_fd_sc_hd__decap_4
X_4363_ net286 net399 _0128_ _0129_ VGND VGND VPWR VPWR _0131_ sky130_fd_sc_hd__nand4_1
XFILLER_113_665 VGND VGND VPWR VPWR sky130_fd_sc_hd__decap_6
X_4294_ _0052_ _0064_ VGND VGND VPWR VPWR _0065_ sky130_fd_sc_hd__and2_1
X_6102_ net283 net437 _1957_ VGND VGND VPWR VPWR _1959_ sky130_fd_sc_hd__a21o_1
XFILLER_112_153 VPWR VGND VPWR VGND sky130_ef_sc_hd__decap_12
XFILLER_98_387 VPWR VGND VPWR VGND sky130_ef_sc_hd__decap_12
X_6033_ net403 net395 net272 net269 VGND VGND VPWR VPWR _1883_ sky130_fd_sc_hd__and4_1
XFILLER_112_197 VGND VGND VPWR VPWR sky130_fd_sc_hd__decap_4
XFILLER_66_240 VPWR VGND VPWR VGND sky130_ef_sc_hd__decap_12
XTAP_TAPCELL_ROW_107_1539 VGND VPWR sky130_fd_sc_hd__tapvpwrvgnd_1
XTAP_TAPCELL_ROW_1_258 VGND VPWR sky130_fd_sc_hd__tapvpwrvgnd_1
XFILLER_26_126 VGND VGND VPWR VPWR sky130_fd_sc_hd__fill_1
XFILLER_81_232 VGND VGND VPWR VPWR sky130_fd_sc_hd__fill_1
XTAP_TAPCELL_ROW_1_269 VGND VPWR sky130_fd_sc_hd__tapvpwrvgnd_1
XFILLER_25_27 VPWR VGND VPWR VGND sky130_ef_sc_hd__decap_12
XFILLER_42_608 VPWR VGND VPWR VGND sky130_ef_sc_hd__decap_12
XFILLER_34_170 VGND VGND VPWR VPWR sky130_fd_sc_hd__decap_8
XFILLER_35_671 VGND VGND VPWR VPWR sky130_fd_sc_hd__fill_1
XTAP_TAPCELL_ROW_37_699 VGND VPWR sky130_fd_sc_hd__tapvpwrvgnd_1
XFILLER_22_321 VPWR VGND VPWR VGND sky130_ef_sc_hd__decap_12
X_6866_ _2659_ _2664_ _2792_ VGND VGND VPWR VPWR _2793_ sky130_fd_sc_hd__a21oi_1
X_6797_ net310 net258 net296 net292 VGND VGND VPWR VPWR _2718_ sky130_fd_sc_hd__and4_1
X_5817_ _1478_ _1646_ _1647_ VGND VGND VPWR VPWR _1649_ sky130_fd_sc_hd__and3_1
XFILLER_22_354 VGND VGND VPWR VPWR sky130_fd_sc_hd__fill_2
X_5748_ _1376_ _1378_ _1571_ _1573_ VGND VGND VPWR VPWR _1574_ sky130_fd_sc_hd__a211oi_2
XFILLER_6_509 VPWR VGND VPWR VGND sky130_ef_sc_hd__decap_12
XFILLER_22_387 VPWR VGND VPWR VGND sky130_ef_sc_hd__decap_12
XFILLER_41_15 VPWR VGND VPWR VGND sky130_ef_sc_hd__decap_12
XFILLER_108_426 VPWR VGND VPWR VGND sky130_ef_sc_hd__decap_12
X_5679_ _1496_ _1497_ VGND VGND VPWR VPWR _1498_ sky130_fd_sc_hd__and2b_1
XTAP_TAPCELL_ROW_9_358 VGND VPWR sky130_fd_sc_hd__tapvpwrvgnd_1
XFILLER_1_225 VGND VGND VPWR VPWR sky130_fd_sc_hd__decap_4
XFILLER_104_643 VGND VGND VPWR VPWR sky130_fd_sc_hd__fill_1
XFILLER_77_505 VGND VGND VPWR VPWR sky130_fd_sc_hd__fill_1
XFILLER_106_41 VPWR VGND VPWR VGND sky130_ef_sc_hd__decap_12
XFILLER_106_85 VGND VGND VPWR VPWR sky130_fd_sc_hd__decap_6
XFILLER_66_78 VGND VGND VPWR VPWR sky130_fd_sc_hd__decap_6
XFILLER_66_56 VPWR VGND VPWR VGND sky130_ef_sc_hd__decap_12
XFILLER_66_89 VGND VGND VPWR VPWR sky130_fd_sc_hd__decap_8
XTAP_TAPCELL_ROW_56_920 VGND VPWR sky130_fd_sc_hd__tapvpwrvgnd_1
XFILLER_17_137 VGND VGND VPWR VPWR sky130_fd_sc_hd__decap_6
XFILLER_72_243 VGND VGND VPWR VPWR sky130_fd_sc_hd__decap_8
XFILLER_72_232 VGND VGND VPWR VPWR sky130_fd_sc_hd__decap_4
XFILLER_72_298 VGND VGND VPWR VPWR sky130_fd_sc_hd__decap_8
XFILLER_41_641 VPWR VGND VPWR VGND sky130_ef_sc_hd__decap_12
XFILLER_41_685 VGND VGND VPWR VPWR sky130_fd_sc_hd__decap_6
XFILLER_40_184 VPWR VGND VPWR VGND sky130_ef_sc_hd__decap_12
XTAP_TAPCELL_ROW_97_1421 VGND VPWR sky130_fd_sc_hd__tapvpwrvgnd_1
XTAP_TAPCELL_ROW_97_1410 VGND VPWR sky130_fd_sc_hd__tapvpwrvgnd_1
XFILLER_9_369 VGND VGND VPWR VPWR sky130_fd_sc_hd__decap_3
XFILLER_99_107 VGND VGND VPWR VPWR sky130_fd_sc_hd__decap_4
XFILLER_5_553 VGND VGND VPWR VPWR sky130_fd_sc_hd__decap_6
XFILLER_31_81 VPWR VGND VPWR VGND sky130_ef_sc_hd__decap_12
XFILLER_5_597 VPWR VGND VPWR VGND sky130_ef_sc_hd__decap_12
Xoutput92 net92 VGND VGND VPWR VPWR return_port[23] sky130_fd_sc_hd__clkbuf_4
Xoutput81 net81 VGND VGND VPWR VPWR return_port[13] sky130_fd_sc_hd__clkbuf_4
XFILLER_110_613 VPWR VGND VPWR VGND sky130_ef_sc_hd__decap_12
XFILLER_110_657 VPWR VGND VPWR VGND sky130_ef_sc_hd__decap_12
XFILLER_36_413 VGND VGND VPWR VPWR sky130_fd_sc_hd__decap_6
XFILLER_48_273 VGND VGND VPWR VPWR sky130_fd_sc_hd__decap_6
XFILLER_63_254 VGND VGND VPWR VPWR sky130_fd_sc_hd__fill_2
X_4981_ _0648_ _0650_ _0649_ VGND VGND VPWR VPWR _0739_ sky130_fd_sc_hd__a21bo_1
XFILLER_17_671 VGND VGND VPWR VPWR sky130_fd_sc_hd__fill_1
X_3932_ net126 _3121_ _3122_ VGND VGND VPWR VPWR _3123_ sky130_fd_sc_hd__and3_1
X_6720_ _2458_ _2460_ _2633_ VGND VGND VPWR VPWR _2634_ sky130_fd_sc_hd__a21o_1
XTAP_TAPCELL_ROW_34_658 VGND VPWR sky130_fd_sc_hd__tapvpwrvgnd_1
XFILLER_51_449 VGND VGND VPWR VPWR sky130_fd_sc_hd__fill_1
X_3863_ _3027_ _3052_ VGND VGND VPWR VPWR _3057_ sky130_fd_sc_hd__nand2_1
X_6651_ net448 net445 net340 VGND VGND VPWR VPWR _2558_ sky130_fd_sc_hd__and3_1
X_5602_ net403 net302 _1265_ _1264_ VGND VGND VPWR VPWR _1414_ sky130_fd_sc_hd__a31o_1
X_6582_ _2481_ _2482_ _2305_ _2307_ VGND VGND VPWR VPWR _2484_ sky130_fd_sc_hd__o211a_1
X_3794_ _2988_ _2989_ _2983_ VGND VGND VPWR VPWR _2991_ sky130_fd_sc_hd__o21ai_1
X_5533_ net235 net223 net466 VGND VGND VPWR VPWR _1338_ sky130_fd_sc_hd__and3_1
XFILLER_105_418 VGND VGND VPWR VPWR sky130_fd_sc_hd__decap_3
X_5464_ net403 net302 VGND VGND VPWR VPWR _1263_ sky130_fd_sc_hd__nand2_1
X_4415_ _0145_ _0181_ VGND VGND VPWR VPWR _0182_ sky130_fd_sc_hd__nand2_1
X_5395_ _1071_ _1074_ _1186_ _1187_ VGND VGND VPWR VPWR _1188_ sky130_fd_sc_hd__a211o_1
XFILLER_113_440 VGND VGND VPWR VPWR sky130_fd_sc_hd__decap_8
XFILLER_99_641 VPWR VGND VPWR VGND sky130_ef_sc_hd__decap_12
X_4346_ _0086_ _0113_ VGND VGND VPWR VPWR _0115_ sky130_fd_sc_hd__or2_1
Xfanout304 net41 VGND VGND VPWR VPWR net304 sky130_fd_sc_hd__clkbuf_4
XFILLER_113_473 VPWR VGND VPWR VGND sky130_ef_sc_hd__decap_12
XFILLER_99_685 VGND VGND VPWR VPWR sky130_fd_sc_hd__decap_6
Xfanout337 net339 VGND VGND VPWR VPWR net337 sky130_fd_sc_hd__clkbuf_4
Xfanout326 net328 VGND VGND VPWR VPWR net326 sky130_fd_sc_hd__buf_2
Xfanout348 net353 VGND VGND VPWR VPWR net348 sky130_fd_sc_hd__clkbuf_2
XTAP_TAPCELL_ROW_6_328 VGND VPWR sky130_fd_sc_hd__tapvpwrvgnd_1
Xfanout315 net318 VGND VGND VPWR VPWR net315 sky130_fd_sc_hd__buf_2
X_4277_ net471 net249 VGND VGND VPWR VPWR _0049_ sky130_fd_sc_hd__nand2_1
Xfanout359 net361 VGND VGND VPWR VPWR net359 sky130_fd_sc_hd__clkbuf_4
X_6016_ net452 net419 net264 net257 VGND VGND VPWR VPWR _1864_ sky130_fd_sc_hd__and4_1
XFILLER_36_15 VPWR VGND VPWR VGND sky130_ef_sc_hd__decap_12
XTAP_TAPCELL_ROW_68_1066 VGND VPWR sky130_fd_sc_hd__tapvpwrvgnd_1
XFILLER_42_405 VGND VGND VPWR VPWR sky130_fd_sc_hd__decap_3
XTAP_TAPCELL_ROW_81_1222 VGND VPWR sky130_fd_sc_hd__tapvpwrvgnd_1
XFILLER_23_641 VPWR VGND VPWR VGND sky130_ef_sc_hd__decap_12
XFILLER_23_685 VGND VGND VPWR VPWR sky130_fd_sc_hd__decap_6
X_6849_ _2762_ _2774_ VGND VGND VPWR VPWR _2775_ sky130_fd_sc_hd__xnor2_1
XFILLER_52_25 VGND VGND VPWR VPWR sky130_fd_sc_hd__decap_3
XFILLER_52_47 VGND VGND VPWR VPWR sky130_fd_sc_hd__decap_8
XFILLER_10_346 VGND VGND VPWR VPWR sky130_fd_sc_hd__decap_4
XFILLER_22_195 VGND VGND VPWR VPWR sky130_fd_sc_hd__fill_1
XTAP_TAPCELL_ROW_79_1195 VGND VPWR sky130_fd_sc_hd__tapvpwrvgnd_1
XFILLER_2_501 VPWR VGND VPWR VGND sky130_ef_sc_hd__decap_12
XTAP_TAPCELL_ROW_92_1351 VGND VPWR sky130_fd_sc_hd__tapvpwrvgnd_1
XFILLER_7_3 VPWR VGND VPWR VGND sky130_ef_sc_hd__decap_12
XFILLER_2_545 VPWR VGND VPWR VGND sky130_ef_sc_hd__decap_12
XFILLER_2_589 VPWR VGND VPWR VGND sky130_ef_sc_hd__decap_12
XFILLER_77_99 VGND VGND VPWR VPWR sky130_fd_sc_hd__fill_1
XFILLER_18_435 VPWR VGND VPWR VGND sky130_ef_sc_hd__decap_12
XFILLER_93_54 VGND VGND VPWR VPWR sky130_fd_sc_hd__fill_2
XFILLER_73_541 VPWR VGND VPWR VGND sky130_ef_sc_hd__decap_12
XFILLER_33_405 VGND VGND VPWR VPWR sky130_fd_sc_hd__decap_8
XFILLER_33_449 VPWR VGND VPWR VGND sky130_ef_sc_hd__decap_12
XFILLER_9_122 VGND VGND VPWR VPWR sky130_fd_sc_hd__fill_1
XTAP_TAPCELL_ROW_31_628 VGND VPWR sky130_fd_sc_hd__tapvpwrvgnd_1
XTAP_TAPCELL_ROW_11_385 VGND VPWR sky130_fd_sc_hd__tapvpwrvgnd_1
XFILLER_5_361 VPWR VGND VPWR VGND sky130_ef_sc_hd__decap_12
XFILLER_114_259 VGND VGND VPWR VPWR sky130_fd_sc_hd__decap_6
XFILLER_114_248 VGND VGND VPWR VPWR sky130_fd_sc_hd__decap_4
X_4200_ _3371_ _3378_ net124 VGND VGND VPWR VPWR _3379_ sky130_fd_sc_hd__o21ai_1
X_5180_ _0949_ _0951_ _0952_ VGND VGND VPWR VPWR _0954_ sky130_fd_sc_hd__a21o_1
XFILLER_110_421 VGND VGND VPWR VPWR sky130_fd_sc_hd__fill_2
XFILLER_95_121 VGND VGND VPWR VPWR sky130_fd_sc_hd__decap_3
X_4131_ net436 net257 VGND VGND VPWR VPWR _3313_ sky130_fd_sc_hd__nand2_1
XFILLER_68_357 VGND VGND VPWR VPWR sky130_fd_sc_hd__fill_1
XFILLER_56_519 VGND VGND VPWR VPWR sky130_fd_sc_hd__fill_2
XTAP_TAPCELL_ROW_39_717 VGND VPWR sky130_fd_sc_hd__tapvpwrvgnd_1
X_4062_ _3245_ _3246_ VGND VGND VPWR VPWR _3247_ sky130_fd_sc_hd__and2_1
XFILLER_83_316 VGND VGND VPWR VPWR sky130_fd_sc_hd__decap_3
XFILLER_64_552 VPWR VGND VPWR VGND sky130_ef_sc_hd__decap_12
XFILLER_64_541 VGND VGND VPWR VPWR sky130_fd_sc_hd__decap_3
XFILLER_36_232 VGND VGND VPWR VPWR sky130_fd_sc_hd__decap_8
XTAP_TAPCELL_ROW_19_474 VGND VPWR sky130_fd_sc_hd__tapvpwrvgnd_1
X_4964_ _0719_ _0720_ _0721_ VGND VGND VPWR VPWR _0722_ sky130_fd_sc_hd__and3_1
XTAP_TAPCELL_ROW_19_485 VGND VPWR sky130_fd_sc_hd__tapvpwrvgnd_1
X_3915_ _2938_ _3106_ net152 VGND VGND VPWR VPWR _3107_ sky130_fd_sc_hd__mux2_1
X_6703_ _2438_ _2441_ _2613_ VGND VGND VPWR VPWR _2615_ sky130_fd_sc_hd__nand3_1
X_4895_ _0651_ _0652_ _0653_ VGND VGND VPWR VPWR _0654_ sky130_fd_sc_hd__and3_1
X_3846_ net312 net385 net432 net364 net350 net278 VGND VGND VPWR VPWR _3041_ sky130_fd_sc_hd__mux4_1
X_6634_ _2537_ _2538_ VGND VGND VPWR VPWR _2539_ sky130_fd_sc_hd__xor2_1
X_3777_ _2887_ _2974_ net159 VGND VGND VPWR VPWR _2975_ sky130_fd_sc_hd__mux2_1
X_6565_ _2290_ _2293_ _2464_ VGND VGND VPWR VPWR _2465_ sky130_fd_sc_hd__a21oi_2
XTAP_TAPCELL_ROW_115_1627 VGND VPWR sky130_fd_sc_hd__tapvpwrvgnd_1
X_5516_ _1193_ net111 _1318_ _1319_ VGND VGND VPWR VPWR _1320_ sky130_fd_sc_hd__o211a_1
X_6496_ _2387_ _2388_ VGND VGND VPWR VPWR _2389_ sky130_fd_sc_hd__xnor2_1
X_5447_ _1241_ _1242_ _1231_ VGND VGND VPWR VPWR _1245_ sky130_fd_sc_hd__a21oi_2
X_5378_ _1159_ _1169_ VGND VGND VPWR VPWR _1170_ sky130_fd_sc_hd__xnor2_1
XFILLER_113_281 VPWR VGND VPWR VGND sky130_ef_sc_hd__decap_12
X_4329_ _0095_ _0096_ _0094_ VGND VGND VPWR VPWR _0098_ sky130_fd_sc_hd__o21ai_1
Xfanout156 net157 VGND VGND VPWR VPWR net156 sky130_fd_sc_hd__clkbuf_2
XFILLER_59_335 VGND VGND VPWR VPWR sky130_fd_sc_hd__fill_1
Xfanout145 _1135_ VGND VGND VPWR VPWR net145 sky130_fd_sc_hd__buf_4
Xfanout123 _1953_ VGND VGND VPWR VPWR net123 sky130_fd_sc_hd__clkbuf_4
Xfanout134 _1070_ VGND VGND VPWR VPWR net134 sky130_fd_sc_hd__clkbuf_4
Xfanout189 net191 VGND VGND VPWR VPWR net189 sky130_fd_sc_hd__buf_2
XFILLER_86_165 VGND VGND VPWR VPWR sky130_fd_sc_hd__fill_2
XFILLER_59_357 VGND VGND VPWR VPWR sky130_fd_sc_hd__fill_1
Xfanout178 net7 VGND VGND VPWR VPWR net178 sky130_fd_sc_hd__clkbuf_2
Xfanout167 net169 VGND VGND VPWR VPWR net167 sky130_fd_sc_hd__clkbuf_4
XPHY_EDGE_ROW_114_Right_114 VGND VGND VPWR VPWR sky130_fd_sc_hd__decap_3
XFILLER_47_69 VPWR VGND VPWR VGND sky130_ef_sc_hd__decap_12
XFILLER_55_552 VGND VGND VPWR VPWR sky130_fd_sc_hd__decap_3
XFILLER_55_541 VGND VGND VPWR VPWR sky130_fd_sc_hd__decap_4
XFILLER_70_500 VPWR VGND VPWR VGND sky130_ef_sc_hd__decap_12
XFILLER_63_24 VGND VGND VPWR VPWR sky130_fd_sc_hd__fill_1
XFILLER_15_405 VPWR VGND VPWR VGND sky130_ef_sc_hd__decap_12
XFILLER_82_393 VGND VGND VPWR VPWR sky130_fd_sc_hd__decap_4
XFILLER_70_533 VGND VGND VPWR VPWR sky130_fd_sc_hd__fill_2
XFILLER_15_449 VPWR VGND VPWR VGND sky130_ef_sc_hd__decap_12
XFILLER_30_419 VGND VGND VPWR VPWR sky130_fd_sc_hd__fill_1
XFILLER_23_493 VGND VGND VPWR VPWR sky130_fd_sc_hd__decap_8
XFILLER_7_615 VGND VGND VPWR VPWR sky130_fd_sc_hd__fill_1
XFILLER_12_61 VGND VGND VPWR VPWR sky130_fd_sc_hd__decap_3
XFILLER_10_187 VGND VGND VPWR VPWR sky130_fd_sc_hd__decap_8
XFILLER_88_54 VGND VGND VPWR VPWR sky130_fd_sc_hd__decap_8
XFILLER_2_342 VGND VGND VPWR VPWR sky130_fd_sc_hd__decap_4
XFILLER_77_165 VGND VGND VPWR VPWR sky130_fd_sc_hd__decap_3
XFILLER_77_187 VGND VGND VPWR VPWR sky130_fd_sc_hd__decap_3
XFILLER_18_265 VPWR VGND VPWR VGND sky130_ef_sc_hd__decap_12
XFILLER_37_80 VPWR VGND VPWR VGND sky130_ef_sc_hd__decap_12
XFILLER_73_393 VGND VGND VPWR VPWR sky130_fd_sc_hd__decap_3
XTAP_TAPCELL_ROW_16_444 VGND VPWR sky130_fd_sc_hd__tapvpwrvgnd_1
XFILLER_33_279 VGND VGND VPWR VPWR sky130_fd_sc_hd__fill_1
XTAP_TAPCELL_ROW_44_775 VGND VPWR sky130_fd_sc_hd__tapvpwrvgnd_1
X_3700_ net398 _0917_ VGND VGND VPWR VPWR _2901_ sky130_fd_sc_hd__or2_1
X_4680_ _0437_ _0440_ _0441_ VGND VGND VPWR VPWR _0442_ sky130_fd_sc_hd__nand3_1
X_3631_ net239 _2834_ net117 VGND VGND VPWR VPWR _2835_ sky130_fd_sc_hd__o21ai_1
X_3562_ _1266_ _2270_ _2467_ net120 _2445_ VGND VGND VPWR VPWR _2478_ sky130_fd_sc_hd__a221o_1
X_6350_ net174 net171 net329 net323 VGND VGND VPWR VPWR _2230_ sky130_fd_sc_hd__and4_1
X_5301_ _1082_ _1084_ _0975_ _0977_ VGND VGND VPWR VPWR _1086_ sky130_fd_sc_hd__o211a_1
XFILLER_6_681 VGND VGND VPWR VPWR sky130_fd_sc_hd__decap_8
X_3493_ _0808_ _1244_ VGND VGND VPWR VPWR _1725_ sky130_fd_sc_hd__nand2_1
XFILLER_5_191 VGND VGND VPWR VPWR sky130_fd_sc_hd__decap_8
X_6281_ _1987_ _1990_ _2152_ _2154_ VGND VGND VPWR VPWR _2155_ sky130_fd_sc_hd__a211o_1
X_5232_ _0998_ _1009_ VGND VGND VPWR VPWR _1010_ sky130_fd_sc_hd__and2b_1
X_5163_ _0931_ _0933_ _0865_ _0868_ VGND VGND VPWR VPWR _0935_ sky130_fd_sc_hd__o211ai_2
XTAP_TAPCELL_ROW_110_1568 VGND VPWR sky130_fd_sc_hd__tapvpwrvgnd_1
XFILLER_96_463 VGND VGND VPWR VPWR sky130_fd_sc_hd__fill_2
X_4114_ _3296_ VGND VGND VPWR VPWR _3297_ sky130_fd_sc_hd__inv_2
X_5094_ _0848_ _0858_ _0859_ VGND VGND VPWR VPWR _0860_ sky130_fd_sc_hd__and3_2
XFILLER_56_338 VPWR VGND VPWR VGND sky130_ef_sc_hd__decap_12
XFILLER_56_316 VGND VGND VPWR VPWR sky130_fd_sc_hd__decap_6
XFILLER_84_669 VPWR VGND VPWR VGND sky130_ef_sc_hd__decap_12
X_4045_ _3199_ _3205_ _3229_ VGND VGND VPWR VPWR _3231_ sky130_fd_sc_hd__nand3_1
XFILLER_17_39 VPWR VGND VPWR VGND sky130_ef_sc_hd__decap_12
XTAP_TAPCELL_ROW_65_1036 VGND VPWR sky130_fd_sc_hd__tapvpwrvgnd_1
XFILLER_52_533 VGND VGND VPWR VPWR sky130_fd_sc_hd__fill_1
XFILLER_24_224 VGND VGND VPWR VPWR sky130_fd_sc_hd__fill_1
XFILLER_24_235 VPWR VGND VPWR VGND sky130_ef_sc_hd__decap_12
X_5996_ _1694_ _1698_ _1840_ _1841_ VGND VGND VPWR VPWR _1843_ sky130_fd_sc_hd__a211o_1
X_4947_ net457 net316 net308 net474 VGND VGND VPWR VPWR _0705_ sky130_fd_sc_hd__a22o_1
XFILLER_33_27 VPWR VGND VPWR VGND sky130_ef_sc_hd__decap_12
X_4878_ _0633_ _0634_ _0635_ VGND VGND VPWR VPWR _0637_ sky130_fd_sc_hd__a21o_1
X_3829_ net312 net333 VGND VGND VPWR VPWR _3024_ sky130_fd_sc_hd__and2_1
X_6617_ _2518_ _2519_ VGND VGND VPWR VPWR _2521_ sky130_fd_sc_hd__nor2_1
XFILLER_20_485 VGND VGND VPWR VPWR sky130_fd_sc_hd__fill_1
X_6548_ _1462_ _2446_ VGND VGND VPWR VPWR _2447_ sky130_fd_sc_hd__and2_1
XFILLER_106_557 VPWR VGND VPWR VGND sky130_ef_sc_hd__decap_12
XTAP_TAPCELL_ROW_76_1165 VGND VPWR sky130_fd_sc_hd__tapvpwrvgnd_1
X_6479_ _2370_ _2369_ VGND VGND VPWR VPWR _2371_ sky130_fd_sc_hd__and2b_1
XFILLER_114_41 VPWR VGND VPWR VGND sky130_ef_sc_hd__decap_12
XFILLER_87_485 VGND VGND VPWR VPWR sky130_fd_sc_hd__fill_1
XFILLER_75_614 VGND VGND VPWR VPWR sky130_fd_sc_hd__fill_2
XFILLER_47_316 VPWR VGND VPWR VGND sky130_ef_sc_hd__decap_12
XFILLER_114_85 VPWR VGND VPWR VGND sky130_ef_sc_hd__decap_12
XFILLER_74_135 VGND VGND VPWR VPWR sky130_fd_sc_hd__decap_4
XFILLER_74_179 VGND VGND VPWR VPWR sky130_fd_sc_hd__decap_8
XTAP_TAPCELL_ROW_87_1294 VGND VPWR sky130_fd_sc_hd__tapvpwrvgnd_1
XFILLER_83_691 VGND VGND VPWR VPWR sky130_fd_sc_hd__fill_1
XFILLER_55_393 VPWR VGND VPWR VGND sky130_ef_sc_hd__decap_12
XFILLER_55_382 VGND VGND VPWR VPWR sky130_fd_sc_hd__decap_3
XFILLER_70_341 VGND VGND VPWR VPWR sky130_fd_sc_hd__decap_3
XTAP_TAPCELL_ROW_13_403 VGND VPWR sky130_fd_sc_hd__tapvpwrvgnd_1
XTAP_TAPCELL_ROW_41_745 VGND VPWR sky130_fd_sc_hd__tapvpwrvgnd_1
XFILLER_7_401 VPWR VGND VPWR VGND sky130_ef_sc_hd__decap_12
XFILLER_23_71 VGND VGND VPWR VPWR sky130_fd_sc_hd__fill_1
XFILLER_7_456 VGND VGND VPWR VPWR sky130_fd_sc_hd__decap_3
Xmax_cap109 _1999_ VGND VGND VPWR VPWR net109 sky130_fd_sc_hd__buf_1
XFILLER_3_673 VPWR VGND VPWR VGND sky130_ef_sc_hd__decap_12
XFILLER_66_625 VPWR VGND VPWR VGND sky130_ef_sc_hd__decap_12
XFILLER_65_113 VGND VGND VPWR VPWR sky130_fd_sc_hd__fill_2
XTAP_TAPCELL_ROW_49_834 VGND VPWR sky130_fd_sc_hd__tapvpwrvgnd_1
XFILLER_66_669 VPWR VGND VPWR VGND sky130_ef_sc_hd__decap_12
XTAP_TAPCELL_ROW_49_845 VGND VPWR sky130_fd_sc_hd__tapvpwrvgnd_1
XFILLER_93_466 VPWR VGND VPWR VGND sky130_ef_sc_hd__decap_12
XFILLER_81_617 VPWR VGND VPWR VGND sky130_ef_sc_hd__decap_12
XFILLER_0_53 VGND VGND VPWR VPWR sky130_fd_sc_hd__decap_3
XFILLER_80_116 VPWR VGND VPWR VGND sky130_ef_sc_hd__decap_12
XFILLER_34_533 VGND VGND VPWR VPWR sky130_fd_sc_hd__decap_6
XFILLER_34_544 VPWR VGND VPWR VGND sky130_ef_sc_hd__decap_12
X_5850_ _1682_ _1683_ _1677_ VGND VGND VPWR VPWR _1685_ sky130_fd_sc_hd__a21o_1
X_4801_ _0559_ _0560_ VGND VGND VPWR VPWR _0561_ sky130_fd_sc_hd__and2_1
XFILLER_61_385 VGND VGND VPWR VPWR sky130_fd_sc_hd__decap_6
X_5781_ _1606_ _1607_ VGND VGND VPWR VPWR _1609_ sky130_fd_sc_hd__xor2_1
X_4732_ net228 net362 net432 net241 VGND VGND VPWR VPWR _0493_ sky130_fd_sc_hd__a22o_1
XFILLER_9_51 VGND VGND VPWR VPWR sky130_fd_sc_hd__decap_4
X_4663_ _0421_ _0422_ _0423_ VGND VGND VPWR VPWR _0425_ sky130_fd_sc_hd__nand3_1
X_3614_ _2051_ _2084_ net279 VGND VGND VPWR VPWR _2818_ sky130_fd_sc_hd__mux2_1
X_6402_ _2285_ _2286_ VGND VGND VPWR VPWR _2287_ sky130_fd_sc_hd__nor2_1
X_4594_ net241 net228 net378 net370 VGND VGND VPWR VPWR _0357_ sky130_fd_sc_hd__nand4_1
X_3545_ net163 net385 _2281_ VGND VGND VPWR VPWR _2292_ sky130_fd_sc_hd__a21bo_1
X_6333_ _2208_ _2209_ VGND VGND VPWR VPWR _2211_ sky130_fd_sc_hd__xnor2_1
X_3476_ net179 _1037_ net67 VGND VGND VPWR VPWR _1539_ sky130_fd_sc_hd__and3b_4
X_6264_ net443 net213 _2133_ _2134_ VGND VGND VPWR VPWR _2136_ sky130_fd_sc_hd__a22o_1
X_5215_ _0990_ _0991_ VGND VGND VPWR VPWR _0992_ sky130_fd_sc_hd__nand2_1
X_6195_ _2037_ _2058_ _2059_ VGND VGND VPWR VPWR _2060_ sky130_fd_sc_hd__nand3_2
X_5146_ _0913_ _0914_ _0910_ VGND VGND VPWR VPWR _0916_ sky130_fd_sc_hd__a21o_1
XFILLER_57_636 VPWR VGND VPWR VGND sky130_ef_sc_hd__decap_12
XFILLER_28_27 VGND VGND VPWR VPWR sky130_fd_sc_hd__fill_1
X_5077_ _0839_ _0840_ VGND VGND VPWR VPWR _0842_ sky130_fd_sc_hd__nor2_1
XFILLER_84_477 VPWR VGND VPWR VGND sky130_ef_sc_hd__decap_12
XFILLER_71_105 VGND VGND VPWR VPWR sky130_fd_sc_hd__decap_6
X_4028_ _3210_ _3211_ _3213_ _3200_ VGND VGND VPWR VPWR _3215_ sky130_fd_sc_hd__a31o_1
XFILLER_71_127 VGND VGND VPWR VPWR sky130_fd_sc_hd__fill_2
XFILLER_65_691 VGND VGND VPWR VPWR sky130_fd_sc_hd__fill_1
XFILLER_37_393 VGND VGND VPWR VPWR sky130_fd_sc_hd__decap_8
XFILLER_44_15 VPWR VGND VPWR VGND sky130_ef_sc_hd__decap_12
XFILLER_25_544 VGND VGND VPWR VPWR sky130_fd_sc_hd__decap_4
X_5979_ net449 net212 _1822_ _1824_ VGND VGND VPWR VPWR _1826_ sky130_fd_sc_hd__a22o_1
XFILLER_100_65 VGND VGND VPWR VPWR sky130_fd_sc_hd__decap_3
XFILLER_20_282 VPWR VGND VPWR VGND sky130_ef_sc_hd__decap_12
XFILLER_107_3 VPWR VGND VPWR VGND sky130_ef_sc_hd__decap_12
XFILLER_106_332 VGND VGND VPWR VPWR sky130_fd_sc_hd__fill_1
XFILLER_106_321 VGND VGND VPWR VPWR sky130_fd_sc_hd__decap_6
XFILLER_106_365 VPWR VGND VPWR VGND sky130_ef_sc_hd__decap_12
XFILLER_69_89 VGND VGND VPWR VPWR sky130_fd_sc_hd__fill_1
XFILLER_102_560 VPWR VGND VPWR VGND sky130_ef_sc_hd__decap_12
XFILLER_47_113 VGND VGND VPWR VPWR sky130_fd_sc_hd__decap_6
XFILLER_48_636 VGND VGND VPWR VPWR sky130_fd_sc_hd__decap_8
XTAP_TAPCELL_ROW_89_1323 VGND VPWR sky130_fd_sc_hd__tapvpwrvgnd_1
XFILLER_87_293 VPWR VGND VPWR VGND sky130_ef_sc_hd__decap_12
XFILLER_85_55 VGND VGND VPWR VPWR sky130_fd_sc_hd__fill_1
XFILLER_75_444 VGND VGND VPWR VPWR sky130_fd_sc_hd__decap_4
XFILLER_48_669 VPWR VGND VPWR VGND sky130_ef_sc_hd__decap_12
XFILLER_63_628 VPWR VGND VPWR VGND sky130_ef_sc_hd__decap_12
XFILLER_63_606 VGND VGND VPWR VPWR sky130_fd_sc_hd__fill_1
XFILLER_62_105 VGND VGND VPWR VPWR sky130_fd_sc_hd__decap_6
XTAP_TAPCELL_ROW_46_804 VGND VPWR sky130_fd_sc_hd__tapvpwrvgnd_1
XFILLER_75_499 VGND VGND VPWR VPWR sky130_fd_sc_hd__decap_4
XFILLER_16_511 VPWR VGND VPWR VGND sky130_ef_sc_hd__decap_12
XFILLER_62_149 VGND VGND VPWR VPWR sky130_fd_sc_hd__fill_2
XFILLER_55_190 VPWR VGND VPWR VGND sky130_ef_sc_hd__decap_12
XTAP_TAPCELL_ROW_26_561 VGND VPWR sky130_fd_sc_hd__tapvpwrvgnd_1
XFILLER_31_503 VGND VGND VPWR VPWR sky130_fd_sc_hd__fill_1
XFILLER_31_536 VGND VGND VPWR VPWR sky130_fd_sc_hd__decap_4
XFILLER_31_547 VPWR VGND VPWR VGND sky130_ef_sc_hd__decap_12
XFILLER_31_569 VGND VGND VPWR VPWR sky130_fd_sc_hd__fill_2
XFILLER_11_260 VPWR VGND VPWR VGND sky130_ef_sc_hd__decap_12
XFILLER_109_181 VPWR VGND VPWR VGND sky130_ef_sc_hd__decap_12
XFILLER_7_297 VPWR VGND VPWR VGND sky130_ef_sc_hd__decap_12
XFILLER_98_525 VGND VGND VPWR VPWR sky130_fd_sc_hd__decap_6
XFILLER_98_569 VPWR VGND VPWR VGND sky130_ef_sc_hd__decap_12
X_5000_ _0749_ _0755_ _0756_ VGND VGND VPWR VPWR _0758_ sky130_fd_sc_hd__nand3_2
XPHY_EDGE_ROW_0_Left_117 VGND VGND VPWR VPWR sky130_fd_sc_hd__decap_3
XFILLER_22_3 VPWR VGND VPWR VGND sky130_ef_sc_hd__decap_12
XFILLER_47_691 VGND VGND VPWR VPWR sky130_fd_sc_hd__fill_1
X_6882_ net181 _alu_i0.Datapath_i.fu_alu_33673_33851.out1\[8\] VGND VGND VPWR VPWR
+ _alu_i0.Datapath_i.reg_0.reg_out1\[8\] sky130_fd_sc_hd__dfxtp_1
X_5902_ net403 net276 _1591_ _1590_ VGND VGND VPWR VPWR _1741_ sky130_fd_sc_hd__a31oi_1
XFILLER_34_352 VGND VGND VPWR VPWR sky130_fd_sc_hd__decap_8
X_5833_ _1663_ _1664_ VGND VGND VPWR VPWR _1666_ sky130_fd_sc_hd__xor2_1
XFILLER_14_29 VPWR VGND VPWR VGND sky130_ef_sc_hd__decap_12
XFILLER_22_569 VPWR VGND VPWR VGND sky130_ef_sc_hd__decap_12
XFILLER_34_396 VGND VGND VPWR VPWR sky130_fd_sc_hd__decap_8
X_5764_ net420 net411 net272 net269 VGND VGND VPWR VPWR _1590_ sky130_fd_sc_hd__and4_1
X_4715_ net417 net409 net190 net345 VGND VGND VPWR VPWR _0476_ sky130_fd_sc_hd__and4_1
X_5695_ _1512_ _1514_ _1499_ VGND VGND VPWR VPWR _1515_ sky130_fd_sc_hd__o21ai_1
X_4646_ net409 net194 VGND VGND VPWR VPWR _0408_ sky130_fd_sc_hd__nand2_1
XFILLER_116_641 VGND VGND VPWR VPWR sky130_fd_sc_hd__decap_3
X_4577_ _0338_ _0339_ VGND VGND VPWR VPWR _0341_ sky130_fd_sc_hd__xnor2_1
XFILLER_89_503 VGND VGND VPWR VPWR sky130_fd_sc_hd__fill_1
X_6316_ _2181_ _2190_ VGND VGND VPWR VPWR _2192_ sky130_fd_sc_hd__xnor2_1
XFILLER_116_685 VGND VGND VPWR VPWR sky130_fd_sc_hd__decap_6
XFILLER_103_313 VPWR VGND VPWR VGND sky130_ef_sc_hd__decap_12
XTAP_TAPCELL_ROW_73_1124 VGND VPWR sky130_fd_sc_hd__tapvpwrvgnd_1
XFILLER_39_15 VPWR VGND VPWR VGND sky130_ef_sc_hd__decap_12
X_3528_ net164 net440 _2095_ VGND VGND VPWR VPWR _2106_ sky130_fd_sc_hd__a21bo_1
X_3459_ net165 net450 _1342_ VGND VGND VPWR VPWR _1353_ sky130_fd_sc_hd__a21bo_1
X_6247_ _1950_ _1952_ _1949_ VGND VGND VPWR VPWR _2118_ sky130_fd_sc_hd__o21ba_1
X_6178_ net430 net301 VGND VGND VPWR VPWR _2042_ sky130_fd_sc_hd__nand2_1
X_5129_ _0833_ _0835_ _0834_ VGND VGND VPWR VPWR _0898_ sky130_fd_sc_hd__a21bo_1
XFILLER_69_293 VPWR VGND VPWR VGND sky130_ef_sc_hd__decap_12
XFILLER_29_113 VGND VGND VPWR VPWR sky130_fd_sc_hd__decap_6
XFILLER_29_124 VPWR VGND VPWR VGND sky130_ef_sc_hd__decap_12
XFILLER_45_617 VPWR VGND VPWR VGND sky130_ef_sc_hd__decap_12
XFILLER_57_499 VGND VGND VPWR VPWR sky130_fd_sc_hd__decap_4
XTAP_TAPCELL_ROW_84_1264 VGND VPWR sky130_fd_sc_hd__tapvpwrvgnd_1
XFILLER_13_503 VGND VGND VPWR VPWR sky130_fd_sc_hd__fill_1
XTAP_TAPCELL_ROW_23_531 VGND VPWR sky130_fd_sc_hd__tapvpwrvgnd_1
XFILLER_71_57 VGND VGND VPWR VPWR sky130_fd_sc_hd__fill_1
XTAP_TAPCELL_ROW_51_862 VGND VPWR sky130_fd_sc_hd__tapvpwrvgnd_1
XFILLER_107_641 VPWR VGND VPWR VGND sky130_ef_sc_hd__decap_12
XFILLER_4_245 VGND VGND VPWR VPWR sky130_fd_sc_hd__decap_6
XFILLER_107_685 VGND VGND VPWR VPWR sky130_fd_sc_hd__decap_6
XFILLER_106_173 VGND VGND VPWR VPWR sky130_fd_sc_hd__decap_8
XTAP_TAPCELL_ROW_95_1393 VGND VPWR sky130_fd_sc_hd__tapvpwrvgnd_1
XFILLER_4_289 VPWR VGND VPWR VGND sky130_ef_sc_hd__decap_12
XFILLER_106_195 VGND VGND VPWR VPWR sky130_fd_sc_hd__fill_1
XFILLER_67_208 VGND VGND VPWR VPWR sky130_fd_sc_hd__fill_1
XFILLER_0_473 VGND VGND VPWR VPWR sky130_fd_sc_hd__decap_3
XFILLER_63_403 VPWR VGND VPWR VGND sky130_ef_sc_hd__decap_12
XTAP_TAPCELL_ROW_59_962 VGND VPWR sky130_fd_sc_hd__tapvpwrvgnd_1
XFILLER_29_81 VPWR VGND VPWR VGND sky130_ef_sc_hd__decap_12
XPHY_EDGE_ROW_82_Left_199 VGND VGND VPWR VPWR sky130_fd_sc_hd__decap_3
XFILLER_90_277 VGND VGND VPWR VPWR sky130_fd_sc_hd__decap_8
XFILLER_16_363 VGND VGND VPWR VPWR sky130_fd_sc_hd__fill_1
XFILLER_45_80 VGND VGND VPWR VPWR sky130_fd_sc_hd__decap_4
XFILLER_31_344 VGND VGND VPWR VPWR sky130_fd_sc_hd__decap_6
XFILLER_43_193 VPWR VGND VPWR VGND sky130_ef_sc_hd__decap_12
XFILLER_31_399 VPWR VGND VPWR VGND sky130_ef_sc_hd__decap_12
X_4500_ _0196_ _0264_ VGND VGND VPWR VPWR _0265_ sky130_fd_sc_hd__and2_1
X_5480_ net369 net360 net331 net325 VGND VGND VPWR VPWR _1281_ sky130_fd_sc_hd__and4_1
X_4431_ _0157_ _0195_ VGND VGND VPWR VPWR _0197_ sky130_fd_sc_hd__nor2_1
XANTENNA_1 _2868_ VGND VGND VPWR VPWR sky130_fd_sc_hd__diode_2
XFILLER_6_41 VPWR VGND VPWR VGND sky130_ef_sc_hd__decap_12
XFILLER_6_85 VGND VGND VPWR VPWR sky130_fd_sc_hd__decap_8
X_4362_ net286 net398 _0128_ _0129_ VGND VGND VPWR VPWR _0130_ sky130_fd_sc_hd__a22o_1
XFILLER_112_121 VPWR VGND VPWR VGND sky130_ef_sc_hd__decap_12
XFILLER_98_344 VGND VGND VPWR VPWR sky130_fd_sc_hd__decap_3
X_4293_ _1735_ _0063_ VGND VGND VPWR VPWR _0064_ sky130_fd_sc_hd__xor2_1
X_6101_ net283 net437 _1957_ VGND VGND VPWR VPWR _1958_ sky130_fd_sc_hd__nand3_1
XFILLER_112_165 VPWR VGND VPWR VGND sky130_ef_sc_hd__decap_12
XFILLER_86_517 VGND VGND VPWR VPWR sky130_fd_sc_hd__fill_1
X_6032_ _1880_ _1881_ VGND VGND VPWR VPWR _1882_ sky130_fd_sc_hd__xnor2_1
XFILLER_39_400 VPWR VGND VPWR VGND sky130_ef_sc_hd__decap_12
XFILLER_27_617 VPWR VGND VPWR VGND sky130_ef_sc_hd__decap_12
XFILLER_26_105 VGND VGND VPWR VPWR sky130_fd_sc_hd__fill_1
XFILLER_26_116 VGND VGND VPWR VPWR sky130_fd_sc_hd__decap_3
XTAP_TAPCELL_ROW_1_259 VGND VPWR sky130_fd_sc_hd__tapvpwrvgnd_1
XFILLER_26_149 VGND VGND VPWR VPWR sky130_fd_sc_hd__decap_3
XFILLER_25_39 VPWR VGND VPWR VGND sky130_ef_sc_hd__decap_12
XFILLER_22_333 VGND VGND VPWR VPWR sky130_fd_sc_hd__fill_2
X_6865_ _2667_ _2791_ VGND VGND VPWR VPWR _2792_ sky130_fd_sc_hd__xnor2_1
X_5816_ _1643_ _1645_ _1629_ VGND VGND VPWR VPWR _1647_ sky130_fd_sc_hd__o21ai_1
X_6796_ net419 _2715_ _2502_ VGND VGND VPWR VPWR _2716_ sky130_fd_sc_hd__mux2_1
XFILLER_22_399 VPWR VGND VPWR VGND sky130_ef_sc_hd__decap_12
XFILLER_41_27 VGND VGND VPWR VPWR sky130_fd_sc_hd__decap_8
X_5747_ _1569_ _1570_ _1436_ _1439_ VGND VGND VPWR VPWR _1573_ sky130_fd_sc_hd__a211oi_1
XFILLER_108_405 VPWR VGND VPWR VGND sky130_ef_sc_hd__decap_12
XFILLER_108_438 VPWR VGND VPWR VGND sky130_ef_sc_hd__decap_12
X_5678_ _1492_ _1493_ _1494_ VGND VGND VPWR VPWR _1497_ sky130_fd_sc_hd__a21o_1
X_4629_ _0389_ _0391_ VGND VGND VPWR VPWR _0392_ sky130_fd_sc_hd__nand2_1
XFILLER_1_204 VGND VGND VPWR VPWR sky130_fd_sc_hd__fill_2
XTAP_TAPCELL_ROW_9_359 VGND VPWR sky130_fd_sc_hd__tapvpwrvgnd_1
XFILLER_106_53 VPWR VGND VPWR VGND sky130_ef_sc_hd__decap_12
XFILLER_89_377 VPWR VGND VPWR VGND sky130_ef_sc_hd__decap_12
XFILLER_103_187 VGND VGND VPWR VPWR sky130_fd_sc_hd__fill_1
XFILLER_85_561 VPWR VGND VPWR VGND sky130_ef_sc_hd__decap_12
XFILLER_66_68 VGND VGND VPWR VPWR sky130_fd_sc_hd__decap_3
XFILLER_72_222 VGND VGND VPWR VPWR sky130_fd_sc_hd__fill_1
XTAP_TAPCELL_ROW_56_921 VGND VPWR sky130_fd_sc_hd__tapvpwrvgnd_1
XFILLER_60_428 VGND VGND VPWR VPWR sky130_fd_sc_hd__fill_1
XFILLER_40_141 VPWR VGND VPWR VGND sky130_ef_sc_hd__decap_12
XFILLER_41_653 VPWR VGND VPWR VGND sky130_ef_sc_hd__decap_12
XTAP_TAPCELL_ROW_97_1411 VGND VPWR sky130_fd_sc_hd__tapvpwrvgnd_1
XFILLER_31_93 VPWR VGND VPWR VGND sky130_ef_sc_hd__decap_12
Xoutput93 net93 VGND VGND VPWR VPWR return_port[24] sky130_fd_sc_hd__clkbuf_4
Xoutput82 net82 VGND VGND VPWR VPWR return_port[14] sky130_fd_sc_hd__clkbuf_4
XFILLER_110_625 VPWR VGND VPWR VGND sky130_ef_sc_hd__decap_12
XFILLER_68_528 VGND VGND VPWR VPWR sky130_fd_sc_hd__decap_4
XFILLER_110_669 VPWR VGND VPWR VGND sky130_ef_sc_hd__decap_12
XPHY_EDGE_ROW_90_Left_207 VGND VGND VPWR VPWR sky130_fd_sc_hd__decap_3
XFILLER_36_436 VGND VGND VPWR VPWR sky130_fd_sc_hd__decap_4
XFILLER_48_263 VGND VGND VPWR VPWR sky130_fd_sc_hd__decap_3
XFILLER_91_553 VGND VGND VPWR VPWR sky130_fd_sc_hd__decap_6
XFILLER_63_233 VGND VGND VPWR VPWR sky130_fd_sc_hd__fill_2
X_4980_ net162 _0830_ _0734_ _0736_ VGND VGND VPWR VPWR _0738_ sky130_fd_sc_hd__or4b_1
X_3931_ _3096_ _3120_ _3114_ VGND VGND VPWR VPWR _3122_ sky130_fd_sc_hd__a21o_1
XTAP_TAPCELL_ROW_34_659 VGND VPWR sky130_fd_sc_hd__tapvpwrvgnd_1
X_3862_ net333 net312 VGND VGND VPWR VPWR _3056_ sky130_fd_sc_hd__nand2b_1
X_6650_ net445 net185 net340 net448 VGND VGND VPWR VPWR _2557_ sky130_fd_sc_hd__a22o_1
X_6581_ _2305_ _2307_ _2481_ _2482_ VGND VGND VPWR VPWR _2483_ sky130_fd_sc_hd__a211oi_2
X_5601_ _1296_ _1298_ VGND VGND VPWR VPWR _1413_ sky130_fd_sc_hd__nand2_1
X_3793_ _2983_ _2988_ _2989_ VGND VGND VPWR VPWR _2990_ sky130_fd_sc_hd__or3_1
XFILLER_31_196 VGND VGND VPWR VPWR sky130_fd_sc_hd__fill_2
X_5532_ net223 net467 net463 net235 VGND VGND VPWR VPWR _1337_ sky130_fd_sc_hd__a22o_1
X_5463_ _1259_ _1261_ VGND VGND VPWR VPWR _1262_ sky130_fd_sc_hd__nor2_1
X_4414_ _0178_ _0179_ VGND VGND VPWR VPWR _0181_ sky130_fd_sc_hd__xnor2_1
X_5394_ _1170_ _1185_ VGND VGND VPWR VPWR _1187_ sky130_fd_sc_hd__and2_1
XFILLER_99_653 VPWR VGND VPWR VGND sky130_ef_sc_hd__decap_12
X_4345_ _0086_ _0113_ VGND VGND VPWR VPWR _0114_ sky130_fd_sc_hd__and2_1
Xfanout305 net40 VGND VGND VPWR VPWR net305 sky130_fd_sc_hd__buf_2
Xfanout338 net339 VGND VGND VPWR VPWR net338 sky130_fd_sc_hd__clkbuf_4
Xfanout327 net328 VGND VGND VPWR VPWR net327 sky130_fd_sc_hd__clkbuf_4
XFILLER_98_141 VGND VGND VPWR VPWR sky130_fd_sc_hd__decap_6
Xfanout316 net318 VGND VGND VPWR VPWR net316 sky130_fd_sc_hd__buf_4
XTAP_TAPCELL_ROW_6_329 VGND VPWR sky130_fd_sc_hd__tapvpwrvgnd_1
XTAP_TAPCELL_ROW_6_318 VGND VPWR sky130_fd_sc_hd__tapvpwrvgnd_1
XFILLER_113_485 VPWR VGND VPWR VGND sky130_ef_sc_hd__decap_12
Xfanout349 net353 VGND VGND VPWR VPWR net349 sky130_fd_sc_hd__clkbuf_4
X_4276_ _alu_i0.Datapath_i.reg_0.reg_out1\[1\] _0048_ net148 VGND VGND VPWR VPWR net88
+ sky130_fd_sc_hd__mux2_1
XFILLER_100_168 VPWR VGND VPWR VGND sky130_ef_sc_hd__decap_12
X_6015_ _alu_i0.Datapath_i.reg_0.reg_out1\[25\] _1863_ net147 VGND VGND VPWR VPWR
+ net94 sky130_fd_sc_hd__mux2_1
XFILLER_94_380 VPWR VGND VPWR VGND sky130_ef_sc_hd__decap_12
XFILLER_36_27 VGND VGND VPWR VPWR sky130_fd_sc_hd__fill_1
XFILLER_15_609 VGND VGND VPWR VPWR sky130_fd_sc_hd__decap_6
XFILLER_27_447 VGND VGND VPWR VPWR sky130_fd_sc_hd__fill_1
XTAP_TAPCELL_ROW_68_1067 VGND VPWR sky130_fd_sc_hd__tapvpwrvgnd_1
XTAP_TAPCELL_ROW_81_1223 VGND VPWR sky130_fd_sc_hd__tapvpwrvgnd_1
XFILLER_52_15 VGND VGND VPWR VPWR sky130_fd_sc_hd__decap_4
XFILLER_23_653 VPWR VGND VPWR VGND sky130_ef_sc_hd__decap_12
X_6848_ _2765_ _2773_ VGND VGND VPWR VPWR _2774_ sky130_fd_sc_hd__xnor2_1
X_6779_ _2696_ _2697_ VGND VGND VPWR VPWR _2698_ sky130_fd_sc_hd__xnor2_1
XFILLER_108_246 VGND VGND VPWR VPWR sky130_fd_sc_hd__fill_2
XTAP_TAPCELL_ROW_79_1196 VGND VPWR sky130_fd_sc_hd__tapvpwrvgnd_1
XFILLER_2_513 VPWR VGND VPWR VGND sky130_ef_sc_hd__decap_12
XTAP_TAPCELL_ROW_92_1352 VGND VPWR sky130_fd_sc_hd__tapvpwrvgnd_1
XFILLER_2_557 VPWR VGND VPWR VGND sky130_ef_sc_hd__decap_12
XFILLER_104_485 VGND VGND VPWR VPWR sky130_fd_sc_hd__decap_3
XFILLER_77_325 VGND VGND VPWR VPWR sky130_fd_sc_hd__decap_8
XFILLER_92_317 VGND VGND VPWR VPWR sky130_fd_sc_hd__fill_2
XFILLER_85_380 VGND VGND VPWR VPWR sky130_fd_sc_hd__fill_1
XFILLER_18_403 VPWR VGND VPWR VGND sky130_ef_sc_hd__decap_12
XFILLER_45_200 VGND VGND VPWR VPWR sky130_fd_sc_hd__decap_4
XFILLER_45_211 VPWR VGND VPWR VGND sky130_ef_sc_hd__decap_12
XFILLER_73_553 VGND VGND VPWR VPWR sky130_fd_sc_hd__decap_6
XFILLER_18_447 VGND VGND VPWR VPWR sky130_fd_sc_hd__decap_3
XFILLER_45_233 VGND VGND VPWR VPWR sky130_fd_sc_hd__decap_3
XFILLER_93_99 VGND VGND VPWR VPWR sky130_fd_sc_hd__fill_1
XFILLER_73_597 VGND VGND VPWR VPWR sky130_fd_sc_hd__fill_2
XTAP_TAPCELL_ROW_31_618 VGND VPWR sky130_fd_sc_hd__tapvpwrvgnd_1
XTAP_TAPCELL_ROW_31_629 VGND VPWR sky130_fd_sc_hd__tapvpwrvgnd_1
XFILLER_41_461 VPWR VGND VPWR VGND sky130_ef_sc_hd__decap_12
XFILLER_9_167 VGND VGND VPWR VPWR sky130_fd_sc_hd__fill_1
XFILLER_61_7 VPWR VGND VPWR VGND sky130_ef_sc_hd__decap_12
XTAP_TAPCELL_ROW_11_386 VGND VPWR sky130_fd_sc_hd__tapvpwrvgnd_1
XFILLER_114_205 VGND VGND VPWR VPWR sky130_fd_sc_hd__fill_2
XFILLER_5_373 VPWR VGND VPWR VGND sky130_ef_sc_hd__decap_12
XFILLER_96_601 VPWR VGND VPWR VGND sky130_ef_sc_hd__decap_12
X_4130_ net436 net257 VGND VGND VPWR VPWR _3312_ sky130_fd_sc_hd__or2_1
XFILLER_96_645 VPWR VGND VPWR VGND sky130_ef_sc_hd__decap_12
XFILLER_96_689 VGND VGND VPWR VPWR sky130_fd_sc_hd__decap_3
XFILLER_95_166 VGND VGND VPWR VPWR sky130_fd_sc_hd__fill_2
XFILLER_3_97 VPWR VGND VPWR VGND sky130_ef_sc_hd__decap_12
X_4061_ net442 net268 VGND VGND VPWR VPWR _3246_ sky130_fd_sc_hd__or2_1
XFILLER_49_561 VGND VGND VPWR VPWR sky130_fd_sc_hd__decap_6
XFILLER_110_477 VPWR VGND VPWR VGND sky130_ef_sc_hd__decap_12
XTAP_TAPCELL_ROW_39_718 VGND VPWR sky130_fd_sc_hd__tapvpwrvgnd_1
XFILLER_49_572 VPWR VGND VPWR VGND sky130_ef_sc_hd__decap_12
XFILLER_76_391 VPWR VGND VPWR VGND sky130_ef_sc_hd__decap_12
XFILLER_64_531 VGND VGND VPWR VPWR sky130_fd_sc_hd__fill_1
XFILLER_91_361 VPWR VGND VPWR VGND sky130_ef_sc_hd__decap_12
XFILLER_64_564 VPWR VGND VPWR VGND sky130_ef_sc_hd__decap_12
X_4963_ _0630_ _0632_ _0631_ VGND VGND VPWR VPWR _0721_ sky130_fd_sc_hd__a21bo_1
XTAP_TAPCELL_ROW_19_475 VGND VPWR sky130_fd_sc_hd__tapvpwrvgnd_1
XFILLER_51_236 VGND VGND VPWR VPWR sky130_fd_sc_hd__fill_2
X_3914_ _3018_ _3105_ net158 VGND VGND VPWR VPWR _3106_ sky130_fd_sc_hd__mux2_1
X_6702_ _2438_ _2441_ _2613_ VGND VGND VPWR VPWR _2614_ sky130_fd_sc_hd__a21o_1
X_4894_ _0564_ _0566_ _0565_ VGND VGND VPWR VPWR _0653_ sky130_fd_sc_hd__a21bo_1
XFILLER_20_601 VPWR VGND VPWR VGND sky130_ef_sc_hd__decap_12
X_6633_ net359 net274 _2366_ _2365_ VGND VGND VPWR VPWR _2538_ sky130_fd_sc_hd__a31o_1
XFILLER_32_483 VGND VGND VPWR VPWR sky130_fd_sc_hd__fill_1
X_3845_ net311 net335 net136 _3039_ VGND VGND VPWR VPWR _3040_ sky130_fd_sc_hd__o31a_1
XFILLER_20_645 VPWR VGND VPWR VGND sky130_ef_sc_hd__decap_12
XFILLER_22_29 VPWR VGND VPWR VGND sky130_ef_sc_hd__decap_12
X_3776_ _2973_ _2936_ net284 VGND VGND VPWR VPWR _2974_ sky130_fd_sc_hd__mux2_1
XFILLER_20_689 VGND VGND VPWR VPWR sky130_fd_sc_hd__decap_3
X_6564_ _2462_ _2463_ VGND VGND VPWR VPWR _2464_ sky130_fd_sc_hd__or2_1
X_5515_ _1257_ _1258_ _1316_ _1317_ VGND VGND VPWR VPWR _1319_ sky130_fd_sc_hd__a2bb2o_1
X_6495_ net445 net193 VGND VGND VPWR VPWR _2388_ sky130_fd_sc_hd__nand2_1
XTAP_TAPCELL_ROW_115_1628 VGND VPWR sky130_fd_sc_hd__tapvpwrvgnd_1
X_5446_ _1231_ _1241_ _1242_ VGND VGND VPWR VPWR _1243_ sky130_fd_sc_hd__and3_2
X_5377_ _1166_ _1167_ VGND VGND VPWR VPWR _1169_ sky130_fd_sc_hd__and2b_1
X_4328_ _0094_ _0095_ _0096_ VGND VGND VPWR VPWR _0097_ sky130_fd_sc_hd__or3_1
Xfanout146 net147 VGND VGND VPWR VPWR net146 sky130_fd_sc_hd__clkbuf_4
Xfanout124 _1953_ VGND VGND VPWR VPWR net124 sky130_fd_sc_hd__clkbuf_4
Xfanout135 net136 VGND VGND VPWR VPWR net135 sky130_fd_sc_hd__buf_2
XFILLER_113_293 VGND VGND VPWR VPWR sky130_fd_sc_hd__fill_2
Xfanout179 net66 VGND VGND VPWR VPWR net179 sky130_fd_sc_hd__clkbuf_2
X_4259_ net140 _0028_ _0032_ net125 VGND VGND VPWR VPWR _0034_ sky130_fd_sc_hd__a2bb2o_1
Xfanout168 net169 VGND VGND VPWR VPWR net168 sky130_fd_sc_hd__clkbuf_4
Xfanout157 _0797_ VGND VGND VPWR VPWR net157 sky130_fd_sc_hd__clkbuf_4
XFILLER_47_15 VPWR VGND VPWR VGND sky130_ef_sc_hd__decap_12
XFILLER_70_512 VGND VGND VPWR VPWR sky130_fd_sc_hd__decap_6
XFILLER_15_417 VPWR VGND VPWR VGND sky130_ef_sc_hd__decap_12
XFILLER_27_266 VPWR VGND VPWR VGND sky130_ef_sc_hd__decap_12
XFILLER_70_556 VGND VGND VPWR VPWR sky130_fd_sc_hd__fill_1
XFILLER_42_269 VGND VGND VPWR VPWR sky130_fd_sc_hd__fill_1
XFILLER_10_100 VGND VGND VPWR VPWR sky130_fd_sc_hd__decap_4
XFILLER_23_483 VGND VGND VPWR VPWR sky130_fd_sc_hd__decap_3
XFILLER_10_111 VPWR VGND VPWR VGND sky130_ef_sc_hd__decap_12
XFILLER_6_148 VGND VGND VPWR VPWR sky130_fd_sc_hd__fill_2
XFILLER_2_332 VGND VGND VPWR VPWR sky130_fd_sc_hd__decap_3
XFILLER_88_66 VPWR VGND VPWR VGND sky130_ef_sc_hd__decap_12
XFILLER_78_601 VPWR VGND VPWR VGND sky130_ef_sc_hd__decap_12
XFILLER_2_365 VGND VGND VPWR VPWR sky130_fd_sc_hd__fill_1
XFILLER_78_645 VPWR VGND VPWR VGND sky130_ef_sc_hd__decap_12
XFILLER_2_387 VGND VGND VPWR VPWR sky130_fd_sc_hd__fill_2
XFILLER_38_509 VPWR VGND VPWR VGND sky130_ef_sc_hd__decap_12
XFILLER_78_689 VGND VGND VPWR VPWR sky130_fd_sc_hd__decap_3
XFILLER_65_306 VGND VGND VPWR VPWR sky130_fd_sc_hd__decap_3
XFILLER_92_136 VGND VGND VPWR VPWR sky130_fd_sc_hd__decap_4
XFILLER_46_531 VGND VGND VPWR VPWR sky130_fd_sc_hd__fill_1
XFILLER_80_309 VPWR VGND VPWR VGND sky130_ef_sc_hd__decap_12
XFILLER_61_501 VGND VGND VPWR VPWR sky130_fd_sc_hd__decap_3
XFILLER_18_277 VGND VGND VPWR VPWR sky130_fd_sc_hd__decap_8
XFILLER_33_203 VGND VGND VPWR VPWR sky130_fd_sc_hd__fill_1
XFILLER_37_92 VPWR VGND VPWR VGND sky130_ef_sc_hd__decap_12
XFILLER_33_225 VGND VGND VPWR VPWR sky130_fd_sc_hd__decap_8
XTAP_TAPCELL_ROW_16_445 VGND VPWR sky130_fd_sc_hd__tapvpwrvgnd_1
XFILLER_33_269 VGND VGND VPWR VPWR sky130_fd_sc_hd__fill_2
XTAP_TAPCELL_ROW_44_776 VGND VPWR sky130_fd_sc_hd__tapvpwrvgnd_1
X_3630_ _2832_ _2833_ net158 VGND VGND VPWR VPWR _2834_ sky130_fd_sc_hd__mux2_1
X_3561_ net156 _1583_ _2456_ VGND VGND VPWR VPWR _2467_ sky130_fd_sc_hd__and3_1
XFILLER_115_503 VGND VGND VPWR VPWR sky130_fd_sc_hd__fill_1
X_5300_ _0975_ _0977_ _1082_ _1084_ VGND VGND VPWR VPWR _1085_ sky130_fd_sc_hd__a211oi_2
XFILLER_52_3 VPWR VGND VPWR VGND sky130_ef_sc_hd__decap_12
X_3492_ net222 _1255_ VGND VGND VPWR VPWR _1714_ sky130_fd_sc_hd__nor2_2
X_6280_ _2149_ _2151_ _1939_ _1941_ VGND VGND VPWR VPWR _2154_ sky130_fd_sc_hd__o211a_1
X_5231_ _0999_ _1008_ VGND VGND VPWR VPWR _1009_ sky130_fd_sc_hd__xnor2_1
X_5162_ _0865_ _0868_ _0931_ _0933_ VGND VGND VPWR VPWR _0934_ sky130_fd_sc_hd__a211o_1
XFILLER_68_100 VGND VGND VPWR VPWR sky130_fd_sc_hd__fill_1
XTAP_TAPCELL_ROW_110_1569 VGND VPWR sky130_fd_sc_hd__tapvpwrvgnd_1
X_5093_ _0849_ _0856_ _0857_ VGND VGND VPWR VPWR _0859_ sky130_fd_sc_hd__nand3_2
X_4113_ net440 _0983_ _3294_ net442 _3295_ VGND VGND VPWR VPWR _3296_ sky130_fd_sc_hd__a221o_1
XFILLER_110_274 VPWR VGND VPWR VGND sky130_ef_sc_hd__decap_12
XFILLER_68_188 VGND VGND VPWR VPWR sky130_fd_sc_hd__decap_8
X_4044_ _3199_ _3205_ _3229_ VGND VGND VPWR VPWR _3230_ sky130_fd_sc_hd__a21o_1
XFILLER_37_575 VPWR VGND VPWR VGND sky130_ef_sc_hd__decap_12
XFILLER_92_681 VGND VGND VPWR VPWR sky130_fd_sc_hd__decap_8
XTAP_TAPCELL_ROW_65_1037 VGND VPWR sky130_fd_sc_hd__tapvpwrvgnd_1
XTAP_TAPCELL_ROW_65_1026 VGND VPWR sky130_fd_sc_hd__tapvpwrvgnd_1
XFILLER_64_383 VPWR VGND VPWR VGND sky130_ef_sc_hd__decap_12
XFILLER_52_567 VGND VGND VPWR VPWR sky130_fd_sc_hd__fill_1
XFILLER_24_247 VGND VGND VPWR VPWR sky130_fd_sc_hd__decap_4
X_5995_ _1694_ _1698_ _1840_ _1841_ VGND VGND VPWR VPWR _1842_ sky130_fd_sc_hd__a211oi_2
X_4946_ net474 net457 net316 net308 VGND VGND VPWR VPWR _0704_ sky130_fd_sc_hd__and4_1
XFILLER_52_589 VGND VGND VPWR VPWR sky130_fd_sc_hd__fill_2
XFILLER_33_39 VPWR VGND VPWR VGND sky130_ef_sc_hd__decap_12
X_4877_ _0633_ _0634_ _0635_ VGND VGND VPWR VPWR _0636_ sky130_fd_sc_hd__and3_1
X_3828_ net121 _3021_ _3023_ _3016_ VGND VGND VPWR VPWR _alu_i0.Datapath_i.fu_alu_33673_33851.out1\[11\]
+ sky130_fd_sc_hd__a211o_1
X_6616_ _2508_ _2517_ VGND VGND VPWR VPWR _2519_ sky130_fd_sc_hd__nor2_1
XFILLER_20_453 VGND VGND VPWR VPWR sky130_fd_sc_hd__fill_1
X_6547_ _2442_ _2443_ VGND VGND VPWR VPWR _2446_ sky130_fd_sc_hd__xor2_1
X_3759_ _1604_ _2957_ net155 VGND VGND VPWR VPWR _2958_ sky130_fd_sc_hd__mux2_1
XTAP_TAPCELL_ROW_76_1166 VGND VPWR sky130_fd_sc_hd__tapvpwrvgnd_1
X_6478_ _2205_ _2207_ _2203_ VGND VGND VPWR VPWR _2370_ sky130_fd_sc_hd__o21ba_1
XFILLER_106_569 VPWR VGND VPWR VGND sky130_ef_sc_hd__decap_12
X_5429_ _1223_ _1224_ VGND VGND VPWR VPWR _1225_ sky130_fd_sc_hd__xnor2_1
XFILLER_87_420 VPWR VGND VPWR VGND sky130_ef_sc_hd__decap_12
XFILLER_101_241 VGND VGND VPWR VPWR sky130_fd_sc_hd__fill_1
XFILLER_59_177 VGND VGND VPWR VPWR sky130_fd_sc_hd__fill_1
XFILLER_47_328 VGND VGND VPWR VPWR sky130_fd_sc_hd__decap_8
XFILLER_114_53 VPWR VGND VPWR VGND sky130_ef_sc_hd__decap_12
XFILLER_28_531 VGND VGND VPWR VPWR sky130_fd_sc_hd__fill_1
XFILLER_114_97 VPWR VGND VPWR VGND sky130_ef_sc_hd__decap_12
XFILLER_74_169 VGND VGND VPWR VPWR sky130_fd_sc_hd__fill_2
XFILLER_62_309 VPWR VGND VPWR VGND sky130_ef_sc_hd__decap_12
XTAP_TAPCELL_ROW_87_1295 VGND VPWR sky130_fd_sc_hd__tapvpwrvgnd_1
XFILLER_70_320 VGND VGND VPWR VPWR sky130_fd_sc_hd__decap_6
XFILLER_15_225 VPWR VGND VPWR VGND sky130_ef_sc_hd__decap_12
XTAP_TAPCELL_ROW_13_404 VGND VPWR sky130_fd_sc_hd__tapvpwrvgnd_1
XTAP_TAPCELL_ROW_41_746 VGND VPWR sky130_fd_sc_hd__tapvpwrvgnd_1
XFILLER_7_413 VGND VGND VPWR VPWR sky130_fd_sc_hd__decap_8
XFILLER_11_486 VGND VGND VPWR VPWR sky130_fd_sc_hd__decap_3
XFILLER_3_641 VPWR VGND VPWR VGND sky130_ef_sc_hd__decap_12
XFILLER_3_685 VGND VGND VPWR VPWR sky130_fd_sc_hd__decap_6
XFILLER_78_475 VGND VGND VPWR VPWR sky130_fd_sc_hd__fill_1
XFILLER_66_637 VGND VGND VPWR VPWR sky130_fd_sc_hd__decap_6
XFILLER_38_306 VGND VGND VPWR VPWR sky130_fd_sc_hd__fill_2
XTAP_TAPCELL_ROW_49_835 VGND VPWR sky130_fd_sc_hd__tapvpwrvgnd_1
XFILLER_93_478 VGND VGND VPWR VPWR sky130_fd_sc_hd__decap_4
XFILLER_81_629 VPWR VGND VPWR VGND sky130_ef_sc_hd__decap_12
XFILLER_46_350 VPWR VGND VPWR VGND sky130_ef_sc_hd__decap_12
XFILLER_74_681 VGND VGND VPWR VPWR sky130_fd_sc_hd__decap_8
XFILLER_0_65 VGND VGND VPWR VPWR sky130_fd_sc_hd__decap_3
X_4800_ _0543_ _0558_ VGND VGND VPWR VPWR _0560_ sky130_fd_sc_hd__nand2_1
XFILLER_34_556 VGND VGND VPWR VPWR sky130_fd_sc_hd__decap_4
X_5780_ _1606_ _1607_ VGND VGND VPWR VPWR _1608_ sky130_fd_sc_hd__nor2_1
XFILLER_34_589 VPWR VGND VPWR VGND sky130_ef_sc_hd__decap_12
X_4731_ net241 net228 net362 net432 VGND VGND VPWR VPWR _0492_ sky130_fd_sc_hd__nand4_1
X_4662_ _0422_ _0423_ _0421_ VGND VGND VPWR VPWR _0424_ sky130_fd_sc_hd__a21o_1
XFILLER_9_74 VGND VGND VPWR VPWR sky130_fd_sc_hd__decap_8
X_3613_ net124 _2815_ _2816_ _2812_ VGND VGND VPWR VPWR _2817_ sky130_fd_sc_hd__a31o_1
X_6401_ net445 net442 net207 net200 VGND VGND VPWR VPWR _2286_ sky130_fd_sc_hd__and4_1
X_4593_ net252 net362 VGND VGND VPWR VPWR _0356_ sky130_fd_sc_hd__and2_1
X_3544_ net352 net311 VGND VGND VPWR VPWR _2281_ sky130_fd_sc_hd__nand2_2
X_6332_ _2209_ _2208_ VGND VGND VPWR VPWR _2210_ sky130_fd_sc_hd__and2b_1
X_3475_ _1397_ _1517_ net236 VGND VGND VPWR VPWR _1528_ sky130_fd_sc_hd__mux2_1
X_6263_ _0863_ _0917_ _2132_ _2134_ VGND VGND VPWR VPWR _2135_ sky130_fd_sc_hd__or4b_2
X_5214_ _0988_ _0989_ _0880_ _0882_ VGND VGND VPWR VPWR _0991_ sky130_fd_sc_hd__a211o_1
X_6194_ _2056_ _2057_ _1871_ VGND VGND VPWR VPWR _2059_ sky130_fd_sc_hd__a21o_1
XFILLER_111_561 VPWR VGND VPWR VGND sky130_ef_sc_hd__decap_12
X_5145_ _0910_ _0913_ _0914_ VGND VGND VPWR VPWR _0915_ sky130_fd_sc_hd__nand3_2
X_5076_ _0836_ _0837_ _0838_ VGND VGND VPWR VPWR _0840_ sky130_fd_sc_hd__a21oi_1
XFILLER_57_648 VPWR VGND VPWR VGND sky130_ef_sc_hd__decap_12
XFILLER_84_489 VGND VGND VPWR VPWR sky130_fd_sc_hd__decap_4
XFILLER_56_158 VPWR VGND VPWR VGND sky130_ef_sc_hd__decap_12
XFILLER_44_309 VPWR VGND VPWR VGND sky130_ef_sc_hd__decap_12
X_4027_ _3200_ _3210_ _3211_ _3213_ VGND VGND VPWR VPWR _3214_ sky130_fd_sc_hd__nand4_1
XFILLER_25_512 VPWR VGND VPWR VGND sky130_ef_sc_hd__decap_12
XFILLER_37_361 VPWR VGND VPWR VGND sky130_ef_sc_hd__decap_12
XFILLER_44_27 VGND VGND VPWR VPWR sky130_fd_sc_hd__fill_1
XFILLER_52_342 VPWR VGND VPWR VGND sky130_ef_sc_hd__decap_12
X_5978_ net449 net212 _1822_ _1824_ VGND VGND VPWR VPWR _1825_ sky130_fd_sc_hd__nand4_2
X_4929_ _0600_ _0686_ _0687_ VGND VGND VPWR VPWR _0688_ sky130_fd_sc_hd__nand3b_1
XFILLER_12_228 VPWR VGND VPWR VGND sky130_ef_sc_hd__decap_12
XFILLER_20_261 VGND VGND VPWR VPWR sky130_fd_sc_hd__fill_2
XFILLER_4_405 VGND VGND VPWR VPWR sky130_fd_sc_hd__decap_6
XFILLER_20_294 VGND VGND VPWR VPWR sky130_fd_sc_hd__fill_2
XFILLER_69_57 VGND VGND VPWR VPWR sky130_fd_sc_hd__fill_2
XFILLER_106_377 VGND VGND VPWR VPWR sky130_fd_sc_hd__fill_1
XFILLER_102_572 VPWR VGND VPWR VGND sky130_ef_sc_hd__decap_12
XFILLER_87_272 VGND VGND VPWR VPWR sky130_fd_sc_hd__decap_8
XFILLER_85_23 VGND VGND VPWR VPWR sky130_fd_sc_hd__fill_2
XTAP_TAPCELL_ROW_89_1324 VGND VPWR sky130_fd_sc_hd__tapvpwrvgnd_1
XFILLER_47_169 VPWR VGND VPWR VGND sky130_ef_sc_hd__decap_12
XTAP_TAPCELL_ROW_46_805 VGND VPWR sky130_fd_sc_hd__tapvpwrvgnd_1
XFILLER_62_117 VGND VGND VPWR VPWR sky130_fd_sc_hd__fill_2
XFILLER_56_681 VGND VGND VPWR VPWR sky130_fd_sc_hd__decap_8
XFILLER_16_523 VGND VGND VPWR VPWR sky130_fd_sc_hd__decap_8
XFILLER_18_83 VGND VGND VPWR VPWR sky130_fd_sc_hd__fill_1
XFILLER_71_673 VPWR VGND VPWR VGND sky130_ef_sc_hd__decap_12
XFILLER_70_150 VGND VGND VPWR VPWR sky130_fd_sc_hd__decap_8
XFILLER_16_589 VPWR VGND VPWR VGND sky130_ef_sc_hd__decap_12
XTAP_TAPCELL_ROW_26_562 VGND VPWR sky130_fd_sc_hd__tapvpwrvgnd_1
XFILLER_70_183 VPWR VGND VPWR VGND sky130_ef_sc_hd__decap_12
XFILLER_31_559 VGND VGND VPWR VPWR sky130_fd_sc_hd__fill_1
XFILLER_11_272 VGND VGND VPWR VPWR sky130_fd_sc_hd__decap_8
XFILLER_109_193 VGND VGND VPWR VPWR sky130_fd_sc_hd__fill_2
XFILLER_66_401 VPWR VGND VPWR VGND sky130_ef_sc_hd__decap_12
XFILLER_38_103 VGND VGND VPWR VPWR sky130_fd_sc_hd__fill_2
XFILLER_39_615 VGND VGND VPWR VPWR sky130_fd_sc_hd__fill_1
XFILLER_15_3 VPWR VGND VPWR VGND sky130_ef_sc_hd__decap_12
XFILLER_38_125 VGND VGND VPWR VPWR sky130_fd_sc_hd__decap_3
XFILLER_93_253 VGND VGND VPWR VPWR sky130_fd_sc_hd__fill_1
XFILLER_81_404 VGND VGND VPWR VPWR sky130_fd_sc_hd__decap_8
XFILLER_26_309 VPWR VGND VPWR VGND sky130_ef_sc_hd__decap_12
XTAP_TAPCELL_ROW_109_1560 VGND VPWR sky130_fd_sc_hd__tapvpwrvgnd_1
X_5901_ _1738_ _1739_ VGND VGND VPWR VPWR _1740_ sky130_fd_sc_hd__xnor2_1
X_6881_ net184 _alu_i0.Datapath_i.fu_alu_33673_33851.out1\[7\] VGND VGND VPWR VPWR
+ _alu_i0.Datapath_i.reg_0.reg_out1\[7\] sky130_fd_sc_hd__dfxtp_1
X_5832_ _1663_ _1664_ VGND VGND VPWR VPWR _1665_ sky130_fd_sc_hd__and2_1
X_5763_ _1587_ _1588_ VGND VGND VPWR VPWR _1589_ sky130_fd_sc_hd__nor2_1
X_4714_ net401 net195 VGND VGND VPWR VPWR _0475_ sky130_fd_sc_hd__nand2_1
XPHY_EDGE_ROW_101_Left_218 VGND VGND VPWR VPWR sky130_fd_sc_hd__decap_3
X_5694_ _1509_ _1510_ _1511_ VGND VGND VPWR VPWR _1514_ sky130_fd_sc_hd__a21oi_1
X_4645_ _alu_i0.Datapath_i.reg_0.reg_out1\[11\] _0407_ net148 VGND VGND VPWR VPWR
+ net79 sky130_fd_sc_hd__mux2_1
XFILLER_30_29 VPWR VGND VPWR VGND sky130_ef_sc_hd__decap_12
X_4576_ _0338_ _0339_ VGND VGND VPWR VPWR _0340_ sky130_fd_sc_hd__or2_1
X_6315_ _2190_ _2181_ VGND VGND VPWR VPWR _2191_ sky130_fd_sc_hd__nand2b_1
X_3527_ net351 net439 VGND VGND VPWR VPWR _2095_ sky130_fd_sc_hd__nand2_2
XFILLER_115_185 VGND VGND VPWR VPWR sky130_fd_sc_hd__fill_1
XFILLER_103_325 VGND VGND VPWR VPWR sky130_fd_sc_hd__decap_4
XTAP_TAPCELL_ROW_73_1125 VGND VPWR sky130_fd_sc_hd__tapvpwrvgnd_1
XPHY_EDGE_ROW_110_Left_227 VGND VGND VPWR VPWR sky130_fd_sc_hd__decap_3
XFILLER_89_559 VGND VGND VPWR VPWR sky130_fd_sc_hd__fill_1
X_3458_ net351 net446 VGND VGND VPWR VPWR _1342_ sky130_fd_sc_hd__nand2_1
XFILLER_39_27 VPWR VGND VPWR VGND sky130_ef_sc_hd__decap_12
X_6246_ _2114_ _2115_ VGND VGND VPWR VPWR _2116_ sky130_fd_sc_hd__xnor2_1
XFILLER_103_369 VGND VGND VPWR VPWR sky130_fd_sc_hd__decap_8
XFILLER_69_250 VPWR VGND VPWR VGND sky130_ef_sc_hd__decap_12
X_6177_ _2038_ _2039_ VGND VGND VPWR VPWR _2041_ sky130_fd_sc_hd__or2_1
X_5128_ _0892_ _0893_ _0894_ VGND VGND VPWR VPWR _0897_ sky130_fd_sc_hd__nand3_1
XFILLER_57_445 VGND VGND VPWR VPWR sky130_fd_sc_hd__decap_3
XFILLER_29_136 VPWR VGND VPWR VGND sky130_ef_sc_hd__decap_12
XFILLER_84_253 VPWR VGND VPWR VGND sky130_ef_sc_hd__decap_12
XFILLER_17_309 VGND VGND VPWR VPWR sky130_fd_sc_hd__decap_6
XFILLER_29_169 VPWR VGND VPWR VGND sky130_ef_sc_hd__decap_12
XFILLER_84_286 VGND VGND VPWR VPWR sky130_fd_sc_hd__decap_8
X_5059_ _0709_ _0820_ VGND VGND VPWR VPWR _0822_ sky130_fd_sc_hd__xnor2_1
XFILLER_55_37 VPWR VGND VPWR VGND sky130_ef_sc_hd__decap_12
XFILLER_38_681 VGND VGND VPWR VPWR sky130_fd_sc_hd__decap_8
XFILLER_45_629 VPWR VGND VPWR VGND sky130_ef_sc_hd__decap_12
XFILLER_25_320 VGND VGND VPWR VPWR sky130_fd_sc_hd__decap_4
XFILLER_44_139 VGND VGND VPWR VPWR sky130_fd_sc_hd__fill_1
XTAP_TAPCELL_ROW_84_1265 VGND VPWR sky130_fd_sc_hd__tapvpwrvgnd_1
XTAP_TAPCELL_ROW_84_1254 VGND VPWR sky130_fd_sc_hd__tapvpwrvgnd_1
XFILLER_53_673 VPWR VGND VPWR VGND sky130_ef_sc_hd__decap_12
XFILLER_80_492 VGND VGND VPWR VPWR sky130_fd_sc_hd__decap_4
XFILLER_80_481 VGND VGND VPWR VPWR sky130_fd_sc_hd__fill_1
XTAP_TAPCELL_ROW_23_532 VGND VPWR sky130_fd_sc_hd__tapvpwrvgnd_1
XFILLER_40_323 VPWR VGND VPWR VGND sky130_ef_sc_hd__decap_12
XTAP_TAPCELL_ROW_51_863 VGND VPWR sky130_fd_sc_hd__tapvpwrvgnd_1
XPHY_EDGE_ROW_109_Right_109 VGND VGND VPWR VPWR sky130_fd_sc_hd__decap_3
XFILLER_107_653 VPWR VGND VPWR VGND sky130_ef_sc_hd__decap_12
XFILLER_106_141 VGND VGND VPWR VPWR sky130_fd_sc_hd__decap_3
XTAP_TAPCELL_ROW_95_1394 VGND VPWR sky130_fd_sc_hd__tapvpwrvgnd_1
XFILLER_96_66 VPWR VGND VPWR VGND sky130_ef_sc_hd__decap_12
XTAP_TAPCELL_ROW_59_963 VGND VPWR sky130_fd_sc_hd__tapvpwrvgnd_1
XFILLER_29_93 VGND VGND VPWR VPWR sky130_fd_sc_hd__decap_3
XFILLER_75_275 VGND VGND VPWR VPWR sky130_fd_sc_hd__decap_4
XFILLER_63_437 VGND VGND VPWR VPWR sky130_fd_sc_hd__decap_8
XFILLER_63_415 VPWR VGND VPWR VGND sky130_ef_sc_hd__decap_12
XTAP_TAPCELL_ROW_3_290 VGND VPWR sky130_fd_sc_hd__tapvpwrvgnd_1
XFILLER_71_470 VPWR VGND VPWR VGND sky130_ef_sc_hd__decap_12
XFILLER_45_92 VGND VGND VPWR VPWR sky130_fd_sc_hd__fill_1
XFILLER_16_386 VGND VGND VPWR VPWR sky130_fd_sc_hd__decap_8
XFILLER_31_334 VGND VGND VPWR VPWR sky130_fd_sc_hd__fill_2
XFILLER_31_367 VGND VGND VPWR VPWR sky130_fd_sc_hd__fill_1
XFILLER_31_378 VGND VGND VPWR VPWR sky130_fd_sc_hd__fill_1
X_4430_ _0157_ _0195_ VGND VGND VPWR VPWR _0196_ sky130_fd_sc_hd__and2_1
XANTENNA_2 _2998_ VGND VGND VPWR VPWR sky130_fd_sc_hd__diode_2
XFILLER_6_53 VPWR VGND VPWR VGND sky130_ef_sc_hd__decap_12
X_4361_ _0125_ _0126_ _0127_ VGND VGND VPWR VPWR _0129_ sky130_fd_sc_hd__a21o_1
XFILLER_98_312 VGND VGND VPWR VPWR sky130_fd_sc_hd__decap_3
X_6100_ _1954_ _1955_ VGND VGND VPWR VPWR _1957_ sky130_fd_sc_hd__xor2_1
XFILLER_112_133 VGND VGND VPWR VPWR sky130_fd_sc_hd__decap_6
X_4292_ _0050_ _0061_ VGND VGND VPWR VPWR _0063_ sky130_fd_sc_hd__xnor2_1
XFILLER_112_177 VGND VGND VPWR VPWR sky130_fd_sc_hd__decap_8
XFILLER_86_529 VGND VGND VPWR VPWR sky130_fd_sc_hd__decap_3
X_6031_ net360 net301 VGND VGND VPWR VPWR _1881_ sky130_fd_sc_hd__nand2_1
XFILLER_39_412 VGND VGND VPWR VPWR sky130_fd_sc_hd__decap_8
XFILLER_39_434 VGND VGND VPWR VPWR sky130_fd_sc_hd__decap_4
XFILLER_66_253 VGND VGND VPWR VPWR sky130_fd_sc_hd__decap_4
XFILLER_54_415 VGND VGND VPWR VPWR sky130_fd_sc_hd__decap_4
XFILLER_27_629 VPWR VGND VPWR VGND sky130_ef_sc_hd__decap_12
X_6864_ _2668_ _2790_ VGND VGND VPWR VPWR _2791_ sky130_fd_sc_hd__xnor2_1
XFILLER_35_673 VPWR VGND VPWR VGND sky130_ef_sc_hd__decap_12
X_5815_ _1629_ _1643_ _1645_ VGND VGND VPWR VPWR _1646_ sky130_fd_sc_hd__or3_2
XFILLER_50_643 VGND VGND VPWR VPWR sky130_fd_sc_hd__fill_1
X_6795_ net419 net54 VGND VGND VPWR VPWR _2715_ sky130_fd_sc_hd__nand2_1
XFILLER_10_529 VGND VGND VPWR VPWR sky130_fd_sc_hd__decap_3
X_5746_ _1436_ _1439_ _1569_ _1570_ VGND VGND VPWR VPWR _1571_ sky130_fd_sc_hd__o211a_1
XFILLER_108_417 VGND VGND VPWR VPWR sky130_fd_sc_hd__decap_3
X_5677_ _1492_ _1493_ _1494_ VGND VGND VPWR VPWR _1496_ sky130_fd_sc_hd__and3_1
X_4628_ _0387_ _0388_ _0351_ VGND VGND VPWR VPWR _0391_ sky130_fd_sc_hd__o21ai_1
XFILLER_116_461 VPWR VGND VPWR VGND sky130_ef_sc_hd__decap_12
X_4559_ _0310_ _0311_ _0322_ VGND VGND VPWR VPWR _0323_ sky130_fd_sc_hd__nand3_1
XFILLER_104_601 VPWR VGND VPWR VGND sky130_ef_sc_hd__decap_12
XFILLER_104_645 VPWR VGND VPWR VGND sky130_ef_sc_hd__decap_12
XFILLER_103_133 VGND VGND VPWR VPWR sky130_fd_sc_hd__fill_2
XFILLER_103_111 VGND VGND VPWR VPWR sky130_fd_sc_hd__fill_1
XFILLER_89_345 VGND VGND VPWR VPWR sky130_fd_sc_hd__decap_8
XFILLER_104_689 VGND VGND VPWR VPWR sky130_fd_sc_hd__decap_3
XFILLER_103_166 VGND VGND VPWR VPWR sky130_fd_sc_hd__fill_2
XFILLER_89_389 VGND VGND VPWR VPWR sky130_fd_sc_hd__decap_3
X_6229_ _1919_ _1928_ _1927_ VGND VGND VPWR VPWR _2098_ sky130_fd_sc_hd__a21bo_1
XFILLER_57_253 VGND VGND VPWR VPWR sky130_fd_sc_hd__decap_4
XFILLER_57_231 VGND VGND VPWR VPWR sky130_fd_sc_hd__fill_2
XFILLER_85_573 VPWR VGND VPWR VGND sky130_ef_sc_hd__decap_12
XFILLER_72_201 VGND VGND VPWR VPWR sky130_fd_sc_hd__fill_1
XFILLER_57_264 VPWR VGND VPWR VGND sky130_ef_sc_hd__decap_12
XTAP_TAPCELL_ROW_56_922 VGND VPWR sky130_fd_sc_hd__tapvpwrvgnd_1
XFILLER_57_297 VGND VGND VPWR VPWR sky130_fd_sc_hd__decap_4
XFILLER_45_459 VGND VGND VPWR VPWR sky130_fd_sc_hd__decap_6
XFILLER_9_316 VGND VGND VPWR VPWR sky130_fd_sc_hd__fill_2
XFILLER_15_51 VGND VGND VPWR VPWR sky130_fd_sc_hd__decap_4
XFILLER_40_153 VGND VGND VPWR VPWR sky130_fd_sc_hd__decap_8
XFILLER_41_665 VGND VGND VPWR VPWR sky130_fd_sc_hd__decap_6
XTAP_TAPCELL_ROW_97_1412 VGND VPWR sky130_fd_sc_hd__tapvpwrvgnd_1
XFILLER_40_197 VPWR VGND VPWR VGND sky130_ef_sc_hd__decap_12
XFILLER_107_461 VGND VGND VPWR VPWR sky130_fd_sc_hd__fill_1
XFILLER_49_9 VPWR VGND VPWR VGND sky130_ef_sc_hd__decap_12
Xoutput83 net83 VGND VGND VPWR VPWR return_port[15] sky130_fd_sc_hd__clkbuf_4
XFILLER_95_315 VPWR VGND VPWR VGND sky130_ef_sc_hd__decap_12
Xoutput94 net94 VGND VGND VPWR VPWR return_port[25] sky130_fd_sc_hd__clkbuf_4
XFILLER_110_637 VGND VGND VPWR VPWR sky130_fd_sc_hd__decap_6
XFILLER_48_253 VGND VGND VPWR VPWR sky130_fd_sc_hd__decap_3
XFILLER_76_573 VGND VGND VPWR VPWR sky130_fd_sc_hd__fill_1
XFILLER_56_80 VGND VGND VPWR VPWR sky130_fd_sc_hd__decap_4
XFILLER_91_565 VGND VGND VPWR VPWR sky130_fd_sc_hd__fill_1
XFILLER_63_289 VGND VGND VPWR VPWR sky130_fd_sc_hd__decap_3
X_3930_ _3095_ _3115_ _3120_ VGND VGND VPWR VPWR _3121_ sky130_fd_sc_hd__or3b_1
XFILLER_17_673 VPWR VGND VPWR VGND sky130_ef_sc_hd__decap_12
XFILLER_16_161 VGND VGND VPWR VPWR sky130_fd_sc_hd__fill_1
X_3861_ _3052_ _3053_ _3054_ _1887_ VGND VGND VPWR VPWR _3055_ sky130_fd_sc_hd__a211o_1
XFILLER_32_643 VGND VGND VPWR VPWR sky130_fd_sc_hd__fill_1
X_3792_ _0819_ net191 _2945_ _2950_ _2967_ VGND VGND VPWR VPWR _2989_ sky130_fd_sc_hd__o221a_1
XFILLER_82_3 VPWR VGND VPWR VGND sky130_ef_sc_hd__decap_12
X_6580_ _2479_ _2480_ _2263_ _2310_ VGND VGND VPWR VPWR _2482_ sky130_fd_sc_hd__a211oi_1
XFILLER_31_153 VGND VGND VPWR VPWR sky130_fd_sc_hd__fill_1
XFILLER_31_175 VGND VGND VPWR VPWR sky130_fd_sc_hd__decap_4
X_5600_ _1402_ _1411_ VGND VGND VPWR VPWR _1412_ sky130_fd_sc_hd__xnor2_1
X_5531_ _alu_i0.Datapath_i.reg_0.reg_out1\[21\] net150 _1335_ _1336_ VGND VGND VPWR
+ VPWR net90 sky130_fd_sc_hd__a22o_1
X_5462_ net275 _1260_ VGND VGND VPWR VPWR _1261_ sky130_fd_sc_hd__and2_1
X_4413_ _0178_ _0179_ VGND VGND VPWR VPWR _0180_ sky130_fd_sc_hd__and2b_1
X_5393_ _1170_ _1185_ VGND VGND VPWR VPWR _1186_ sky130_fd_sc_hd__nor2_2
X_4344_ _0110_ _0111_ VGND VGND VPWR VPWR _0113_ sky130_fd_sc_hd__xor2_1
Xfanout339 net35 VGND VGND VPWR VPWR net339 sky130_fd_sc_hd__clkbuf_4
Xfanout328 net37 VGND VGND VPWR VPWR net328 sky130_fd_sc_hd__buf_2
XFILLER_101_615 VGND VGND VPWR VPWR sky130_fd_sc_hd__fill_1
XFILLER_99_665 VGND VGND VPWR VPWR sky130_fd_sc_hd__decap_6
XTAP_TAPCELL_ROW_6_319 VGND VPWR sky130_fd_sc_hd__tapvpwrvgnd_1
Xfanout317 net318 VGND VGND VPWR VPWR net317 sky130_fd_sc_hd__dlymetal6s2s_1
Xfanout306 net40 VGND VGND VPWR VPWR net306 sky130_fd_sc_hd__buf_2
XFILLER_113_497 VGND VGND VPWR VPWR sky130_fd_sc_hd__decap_6
XFILLER_98_197 VPWR VGND VPWR VGND sky130_ef_sc_hd__decap_12
X_4275_ _1779_ _2663_ _0047_ VGND VGND VPWR VPWR _0048_ sky130_fd_sc_hd__a21oi_1
X_6014_ _1861_ _1862_ VGND VGND VPWR VPWR _1863_ sky130_fd_sc_hd__xnor2_1
XFILLER_39_231 VGND VGND VPWR VPWR sky130_fd_sc_hd__fill_1
XFILLER_94_392 VPWR VGND VPWR VGND sky130_ef_sc_hd__decap_12
XFILLER_82_587 VGND VGND VPWR VPWR sky130_fd_sc_hd__fill_1
XTAP_TAPCELL_ROW_68_1068 VGND VPWR sky130_fd_sc_hd__tapvpwrvgnd_1
XFILLER_54_267 VGND VGND VPWR VPWR sky130_fd_sc_hd__fill_1
XTAP_TAPCELL_ROW_81_1224 VGND VPWR sky130_fd_sc_hd__tapvpwrvgnd_1
XFILLER_23_665 VGND VGND VPWR VPWR sky130_fd_sc_hd__decap_6
X_6847_ _2770_ _2771_ VGND VGND VPWR VPWR _2773_ sky130_fd_sc_hd__and2b_1
XFILLER_50_440 VPWR VGND VPWR VGND sky130_ef_sc_hd__decap_12
XTAP_TAPCELL_ROW_61_980 VGND VPWR sky130_fd_sc_hd__tapvpwrvgnd_1
X_6778_ net277 net22 _2611_ _2609_ VGND VGND VPWR VPWR _2697_ sky130_fd_sc_hd__a31o_1
XFILLER_10_359 VGND VGND VPWR VPWR sky130_fd_sc_hd__decap_4
XFILLER_22_197 VGND VGND VPWR VPWR sky130_fd_sc_hd__decap_4
X_5729_ _1551_ _1552_ _1544_ VGND VGND VPWR VPWR _1553_ sky130_fd_sc_hd__a21o_1
XFILLER_108_225 VGND VGND VPWR VPWR sky130_fd_sc_hd__decap_4
XTAP_TAPCELL_ROW_79_1197 VGND VPWR sky130_fd_sc_hd__tapvpwrvgnd_1
XTAP_TAPCELL_ROW_92_1353 VGND VPWR sky130_fd_sc_hd__tapvpwrvgnd_1
XFILLER_2_525 VGND VGND VPWR VPWR sky130_fd_sc_hd__decap_6
XFILLER_77_35 VGND VGND VPWR VPWR sky130_fd_sc_hd__fill_2
XFILLER_2_569 VPWR VGND VPWR VGND sky130_ef_sc_hd__decap_12
XFILLER_77_337 VGND VGND VPWR VPWR sky130_fd_sc_hd__decap_3
XFILLER_77_57 VGND VGND VPWR VPWR sky130_fd_sc_hd__decap_3
XFILLER_92_307 VGND VGND VPWR VPWR sky130_fd_sc_hd__fill_1
XFILLER_100_681 VGND VGND VPWR VPWR sky130_fd_sc_hd__decap_8
XFILLER_58_573 VPWR VGND VPWR VGND sky130_ef_sc_hd__decap_12
XFILLER_18_415 VGND VGND VPWR VPWR sky130_fd_sc_hd__decap_4
XFILLER_45_223 VGND VGND VPWR VPWR sky130_fd_sc_hd__fill_1
XFILLER_45_267 VPWR VGND VPWR VGND sky130_ef_sc_hd__decap_12
XFILLER_26_83 VGND VGND VPWR VPWR sky130_fd_sc_hd__fill_1
XFILLER_45_289 VPWR VGND VPWR VGND sky130_ef_sc_hd__decap_12
XFILLER_60_259 VGND VGND VPWR VPWR sky130_fd_sc_hd__fill_1
XFILLER_13_142 VPWR VGND VPWR VGND sky130_ef_sc_hd__decap_12
XFILLER_14_643 VGND VGND VPWR VPWR sky130_fd_sc_hd__fill_1
XTAP_TAPCELL_ROW_101_1460 VGND VPWR sky130_fd_sc_hd__tapvpwrvgnd_1
XTAP_TAPCELL_ROW_31_619 VGND VPWR sky130_fd_sc_hd__tapvpwrvgnd_1
XFILLER_41_473 VPWR VGND VPWR VGND sky130_ef_sc_hd__decap_12
XFILLER_9_135 VPWR VGND VPWR VGND sky130_ef_sc_hd__decap_12
XFILLER_9_179 VGND VGND VPWR VPWR sky130_fd_sc_hd__decap_4
XTAP_TAPCELL_ROW_11_387 VGND VPWR sky130_fd_sc_hd__tapvpwrvgnd_1
XFILLER_96_613 VPWR VGND VPWR VGND sky130_ef_sc_hd__decap_12
XFILLER_68_315 VPWR VGND VPWR VGND sky130_ef_sc_hd__decap_12
XFILLER_96_657 VPWR VGND VPWR VGND sky130_ef_sc_hd__decap_12
X_4060_ net442 net268 VGND VGND VPWR VPWR _3245_ sky130_fd_sc_hd__nand2_1
XFILLER_110_489 VPWR VGND VPWR VGND sky130_ef_sc_hd__decap_12
XTAP_TAPCELL_ROW_39_719 VGND VPWR sky130_fd_sc_hd__tapvpwrvgnd_1
XFILLER_64_576 VPWR VGND VPWR VGND sky130_ef_sc_hd__decap_12
XFILLER_36_278 VGND VGND VPWR VPWR sky130_fd_sc_hd__decap_8
XFILLER_91_373 VPWR VGND VPWR VGND sky130_ef_sc_hd__decap_12
X_4962_ _0716_ _0717_ _0718_ VGND VGND VPWR VPWR _0720_ sky130_fd_sc_hd__nand3_1
XTAP_TAPCELL_ROW_19_476 VGND VPWR sky130_fd_sc_hd__tapvpwrvgnd_1
X_4893_ _0648_ _0649_ _0650_ VGND VGND VPWR VPWR _0652_ sky130_fd_sc_hd__nand3_1
X_3913_ _3104_ _3064_ net284 VGND VGND VPWR VPWR _3105_ sky130_fd_sc_hd__mux2_1
X_6701_ _2611_ _2612_ VGND VGND VPWR VPWR _2613_ sky130_fd_sc_hd__xor2_1
XFILLER_51_248 VGND VGND VPWR VPWR sky130_fd_sc_hd__decap_3
XFILLER_51_259 VGND VGND VPWR VPWR sky130_fd_sc_hd__fill_1
X_3844_ net145 _3024_ _3038_ net137 VGND VGND VPWR VPWR _3039_ sky130_fd_sc_hd__a211o_1
XFILLER_20_613 VPWR VGND VPWR VGND sky130_ef_sc_hd__decap_12
X_6632_ _2535_ _2536_ VGND VGND VPWR VPWR _2537_ sky130_fd_sc_hd__xnor2_1
XFILLER_20_657 VPWR VGND VPWR VGND sky130_ef_sc_hd__decap_12
X_3775_ net364 net371 net349 VGND VGND VPWR VPWR _2973_ sky130_fd_sc_hd__mux2_1
X_6563_ _2236_ _2239_ _2461_ VGND VGND VPWR VPWR _2463_ sky130_fd_sc_hd__nor3_1
X_5514_ _1257_ _1258_ _1316_ _1317_ VGND VGND VPWR VPWR _1318_ sky130_fd_sc_hd__or4bb_2
XFILLER_9_691 VGND VGND VPWR VPWR sky130_fd_sc_hd__fill_1
X_6494_ _2385_ _2386_ VGND VGND VPWR VPWR _2387_ sky130_fd_sc_hd__nor2_1
XTAP_TAPCELL_ROW_115_1629 VGND VPWR sky130_fd_sc_hd__tapvpwrvgnd_1
X_5445_ _1232_ _1239_ _1240_ VGND VGND VPWR VPWR _1242_ sky130_fd_sc_hd__nand3_2
XFILLER_105_228 VPWR VGND VPWR VGND sky130_ef_sc_hd__decap_12
X_5376_ _1163_ _1164_ _1165_ VGND VGND VPWR VPWR _1167_ sky130_fd_sc_hd__a21o_1
X_4327_ net225 net454 net422 net238 VGND VGND VPWR VPWR _0096_ sky130_fd_sc_hd__a22oi_2
Xfanout147 net148 VGND VGND VPWR VPWR net147 sky130_fd_sc_hd__buf_4
Xfanout136 _1070_ VGND VGND VPWR VPWR net136 sky130_fd_sc_hd__buf_2
XFILLER_59_337 VPWR VGND VPWR VGND sky130_ef_sc_hd__decap_12
Xfanout125 net127 VGND VGND VPWR VPWR net125 sky130_fd_sc_hd__clkbuf_4
XFILLER_86_145 VGND VGND VPWR VPWR sky130_fd_sc_hd__decap_3
Xfanout158 net160 VGND VGND VPWR VPWR net158 sky130_fd_sc_hd__clkbuf_4
X_4258_ _1887_ _0032_ _0028_ net124 VGND VGND VPWR VPWR _0033_ sky130_fd_sc_hd__a2bb2o_1
Xfanout169 net9 VGND VGND VPWR VPWR net169 sky130_fd_sc_hd__clkbuf_4
XFILLER_47_27 VGND VGND VPWR VPWR sky130_fd_sc_hd__decap_3
XFILLER_74_307 VGND VGND VPWR VPWR sky130_fd_sc_hd__fill_1
X_4189_ _3361_ _3366_ _3368_ VGND VGND VPWR VPWR _alu_i0.Datapath_i.fu_alu_33673_33851.out1\[27\]
+ sky130_fd_sc_hd__or3b_1
XFILLER_103_55 VGND VGND VPWR VPWR sky130_fd_sc_hd__fill_1
XFILLER_15_429 VPWR VGND VPWR VGND sky130_ef_sc_hd__decap_12
XFILLER_27_278 VGND VGND VPWR VPWR sky130_fd_sc_hd__fill_2
XFILLER_10_123 VPWR VGND VPWR VGND sky130_ef_sc_hd__decap_12
XFILLER_7_617 VPWR VGND VPWR VGND sky130_ef_sc_hd__decap_12
XFILLER_12_41 VPWR VGND VPWR VGND sky130_ef_sc_hd__decap_12
XFILLER_12_85 VPWR VGND VPWR VGND sky130_ef_sc_hd__decap_12
XFILLER_12_74 VGND VGND VPWR VPWR sky130_fd_sc_hd__decap_8
XFILLER_88_78 VGND VGND VPWR VPWR sky130_fd_sc_hd__decap_6
XFILLER_78_613 VPWR VGND VPWR VGND sky130_ef_sc_hd__decap_12
XFILLER_93_605 VGND VGND VPWR VPWR sky130_fd_sc_hd__decap_8
XFILLER_78_657 VPWR VGND VPWR VGND sky130_ef_sc_hd__decap_12
XFILLER_77_156 VGND VGND VPWR VPWR sky130_fd_sc_hd__fill_1
XFILLER_92_148 VGND VGND VPWR VPWR sky130_fd_sc_hd__fill_2
XPHY_EDGE_ROW_16_Right_16 VGND VGND VPWR VPWR sky130_fd_sc_hd__decap_3
XFILLER_18_245 VGND VGND VPWR VPWR sky130_fd_sc_hd__decap_6
XFILLER_46_587 VGND VGND VPWR VPWR sky130_fd_sc_hd__fill_1
XTAP_TAPCELL_ROW_16_446 VGND VPWR sky130_fd_sc_hd__tapvpwrvgnd_1
XFILLER_14_473 VGND VGND VPWR VPWR sky130_fd_sc_hd__decap_3
XTAP_TAPCELL_ROW_44_777 VGND VPWR sky130_fd_sc_hd__tapvpwrvgnd_1
XFILLER_41_281 VPWR VGND VPWR VGND sky130_ef_sc_hd__decap_12
X_3560_ net163 net456 _1092_ VGND VGND VPWR VPWR _2456_ sky130_fd_sc_hd__a21o_1
XPHY_EDGE_ROW_25_Right_25 VGND VGND VPWR VPWR sky130_fd_sc_hd__decap_3
XFILLER_115_559 VGND VGND VPWR VPWR sky130_fd_sc_hd__fill_1
X_3491_ _1637_ _1692_ net251 VGND VGND VPWR VPWR _1703_ sky130_fd_sc_hd__mux2_1
X_5230_ _1006_ _1007_ VGND VGND VPWR VPWR _1008_ sky130_fd_sc_hd__nor2_1
XFILLER_102_209 VGND VGND VPWR VPWR sky130_fd_sc_hd__decap_6
XFILLER_45_3 VPWR VGND VPWR VGND sky130_ef_sc_hd__decap_12
X_5161_ _0927_ _0929_ _0824_ VGND VGND VPWR VPWR _0933_ sky130_fd_sc_hd__o21a_1
X_5092_ _0856_ _0857_ _0849_ VGND VGND VPWR VPWR _0858_ sky130_fd_sc_hd__a21o_1
X_4112_ _3253_ _3293_ VGND VGND VPWR VPWR _3295_ sky130_fd_sc_hd__and2b_1
XFILLER_110_253 VGND VGND VPWR VPWR sky130_fd_sc_hd__decap_8
XFILLER_83_104 VGND VGND VPWR VPWR sky130_fd_sc_hd__decap_3
XFILLER_56_307 VGND VGND VPWR VPWR sky130_fd_sc_hd__fill_1
X_4043_ _3224_ _3227_ VGND VGND VPWR VPWR _3229_ sky130_fd_sc_hd__nand2_1
XFILLER_110_286 VPWR VGND VPWR VGND sky130_ef_sc_hd__decap_12
XFILLER_83_137 VPWR VGND VPWR VGND sky130_ef_sc_hd__decap_12
XPHY_EDGE_ROW_34_Right_34 VGND VGND VPWR VPWR sky130_fd_sc_hd__decap_3
XFILLER_83_159 VGND VGND VPWR VPWR sky130_fd_sc_hd__decap_8
XTAP_TAPCELL_ROW_65_1027 VGND VPWR sky130_fd_sc_hd__tapvpwrvgnd_1
XFILLER_64_373 VGND VGND VPWR VPWR sky130_fd_sc_hd__fill_1
XFILLER_24_204 VPWR VGND VPWR VGND sky130_ef_sc_hd__decap_12
X_5994_ _1837_ _1838_ _1650_ _1652_ VGND VGND VPWR VPWR _1841_ sky130_fd_sc_hd__o211a_1
XFILLER_37_587 VPWR VGND VPWR VGND sky130_ef_sc_hd__decap_12
X_4945_ net356 net177 _0659_ _0658_ VGND VGND VPWR VPWR _0703_ sky130_fd_sc_hd__a31o_1
X_4876_ _0549_ _0551_ _0550_ VGND VGND VPWR VPWR _0635_ sky130_fd_sc_hd__a21bo_1
XFILLER_20_421 VPWR VGND VPWR VGND sky130_ef_sc_hd__decap_12
X_3827_ _2825_ _2960_ _3022_ net117 VGND VGND VPWR VPWR _3023_ sky130_fd_sc_hd__a2bb2o_1
X_6615_ _2508_ _2517_ VGND VGND VPWR VPWR _2518_ sky130_fd_sc_hd__and2_1
XPHY_EDGE_ROW_43_Right_43 VGND VGND VPWR VPWR sky130_fd_sc_hd__decap_3
X_3758_ _2861_ _2956_ net160 VGND VGND VPWR VPWR _2957_ sky130_fd_sc_hd__mux2_1
X_6546_ _2442_ _2443_ VGND VGND VPWR VPWR _2444_ sky130_fd_sc_hd__and2b_1
X_3689_ net133 _2870_ _2871_ _2880_ VGND VGND VPWR VPWR _2891_ sky130_fd_sc_hd__a31o_1
XTAP_TAPCELL_ROW_76_1167 VGND VPWR sky130_fd_sc_hd__tapvpwrvgnd_1
X_6477_ _2366_ _2367_ VGND VGND VPWR VPWR _2369_ sky130_fd_sc_hd__xnor2_1
X_5428_ net282 net450 VGND VGND VPWR VPWR _1224_ sky130_fd_sc_hd__and2_1
XFILLER_114_581 VGND VGND VPWR VPWR sky130_fd_sc_hd__decap_6
XFILLER_99_281 VPWR VGND VPWR VGND sky130_ef_sc_hd__decap_12
XFILLER_58_15 VPWR VGND VPWR VGND sky130_ef_sc_hd__decap_12
X_5359_ net412 net303 VGND VGND VPWR VPWR _1149_ sky130_fd_sc_hd__nand2_1
XFILLER_87_432 VPWR VGND VPWR VGND sky130_ef_sc_hd__decap_12
XFILLER_74_104 VGND VGND VPWR VPWR sky130_fd_sc_hd__decap_8
XPHY_EDGE_ROW_52_Right_52 VGND VGND VPWR VPWR sky130_fd_sc_hd__decap_3
XFILLER_114_65 VPWR VGND VPWR VGND sky130_ef_sc_hd__decap_12
XFILLER_101_297 VGND VGND VPWR VPWR sky130_fd_sc_hd__fill_1
XTAP_TAPCELL_ROW_87_1296 VGND VPWR sky130_fd_sc_hd__tapvpwrvgnd_1
XFILLER_83_671 VGND VGND VPWR VPWR sky130_fd_sc_hd__fill_1
XFILLER_15_237 VGND VGND VPWR VPWR sky130_fd_sc_hd__fill_1
XFILLER_15_248 VPWR VGND VPWR VGND sky130_ef_sc_hd__decap_12
XFILLER_43_557 VGND VGND VPWR VPWR sky130_fd_sc_hd__decap_3
XFILLER_70_365 VPWR VGND VPWR VGND sky130_ef_sc_hd__decap_12
XTAP_TAPCELL_ROW_13_405 VGND VPWR sky130_fd_sc_hd__tapvpwrvgnd_1
XFILLER_70_398 VGND VGND VPWR VPWR sky130_fd_sc_hd__fill_1
XPHY_EDGE_ROW_61_Right_61 VGND VGND VPWR VPWR sky130_fd_sc_hd__decap_3
XFILLER_11_432 VGND VGND VPWR VPWR sky130_fd_sc_hd__fill_1
XFILLER_23_281 VPWR VGND VPWR VGND sky130_ef_sc_hd__decap_12
XTAP_TAPCELL_ROW_41_747 VGND VPWR sky130_fd_sc_hd__tapvpwrvgnd_1
XFILLER_11_443 VGND VGND VPWR VPWR sky130_fd_sc_hd__decap_4
XFILLER_23_51 VGND VGND VPWR VPWR sky130_fd_sc_hd__decap_4
XFILLER_23_84 VGND VGND VPWR VPWR sky130_fd_sc_hd__decap_6
XFILLER_99_55 VGND VGND VPWR VPWR sky130_fd_sc_hd__fill_1
XFILLER_7_469 VPWR VGND VPWR VGND sky130_ef_sc_hd__decap_12
XFILLER_3_653 VPWR VGND VPWR VGND sky130_ef_sc_hd__decap_12
XFILLER_2_130 VGND VGND VPWR VPWR sky130_fd_sc_hd__fill_1
XPHY_EDGE_ROW_70_Right_70 VGND VGND VPWR VPWR sky130_fd_sc_hd__decap_3
XFILLER_93_435 VPWR VGND VPWR VGND sky130_ef_sc_hd__decap_12
XTAP_TAPCELL_ROW_49_836 VGND VPWR sky130_fd_sc_hd__tapvpwrvgnd_1
XFILLER_61_310 VGND VGND VPWR VPWR sky130_fd_sc_hd__decap_4
XFILLER_46_362 VGND VGND VPWR VPWR sky130_fd_sc_hd__fill_2
XFILLER_64_91 VGND VGND VPWR VPWR sky130_fd_sc_hd__decap_3
XFILLER_61_332 VGND VGND VPWR VPWR sky130_fd_sc_hd__decap_4
XPHY_EDGE_ROW_14_Left_131 VGND VGND VPWR VPWR sky130_fd_sc_hd__decap_3
XFILLER_0_99 VGND VGND VPWR VPWR sky130_fd_sc_hd__decap_3
XFILLER_34_568 VPWR VGND VPWR VGND sky130_ef_sc_hd__decap_12
X_4730_ net251 net386 VGND VGND VPWR VPWR _0491_ sky130_fd_sc_hd__and2_1
XFILLER_21_229 VGND VGND VPWR VPWR sky130_fd_sc_hd__fill_1
X_4661_ net227 net371 net363 net241 VGND VGND VPWR VPWR _0423_ sky130_fd_sc_hd__a22o_1
XFILLER_9_86 VPWR VGND VPWR VGND sky130_ef_sc_hd__decap_12
X_3612_ _2808_ _2814_ VGND VGND VPWR VPWR _2816_ sky130_fd_sc_hd__or2_1
X_6400_ net443 net205 net198 net445 VGND VGND VPWR VPWR _2285_ sky130_fd_sc_hd__a22oi_1
X_4592_ net291 net431 VGND VGND VPWR VPWR _0355_ sky130_fd_sc_hd__nand2_1
X_6331_ _2046_ _2049_ VGND VGND VPWR VPWR _2209_ sky130_fd_sc_hd__nor2_1
X_3543_ _2139_ _2259_ net239 VGND VGND VPWR VPWR _2270_ sky130_fd_sc_hd__mux2_1
X_3474_ _1452_ _1506_ net246 VGND VGND VPWR VPWR _1517_ sky130_fd_sc_hd__mux2_1
XPHY_EDGE_ROW_23_Left_140 VGND VGND VPWR VPWR sky130_fd_sc_hd__decap_3
X_6262_ net446 net205 net198 net448 VGND VGND VPWR VPWR _2134_ sky130_fd_sc_hd__a22o_1
X_5213_ _0880_ _0882_ _0988_ _0989_ VGND VGND VPWR VPWR _0990_ sky130_fd_sc_hd__o211ai_2
X_6193_ _1871_ _2056_ _2057_ VGND VGND VPWR VPWR _2058_ sky130_fd_sc_hd__nand3_2
X_5144_ net262 net215 _0911_ _0912_ VGND VGND VPWR VPWR _0914_ sky130_fd_sc_hd__nand4_2
XFILLER_111_573 VPWR VGND VPWR VGND sky130_ef_sc_hd__decap_12
XFILLER_28_29 VPWR VGND VPWR VGND sky130_ef_sc_hd__decap_12
X_5075_ _0836_ _0837_ _0838_ VGND VGND VPWR VPWR _0839_ sky130_fd_sc_hd__and3_1
XFILLER_56_137 VGND VGND VPWR VPWR sky130_fd_sc_hd__decap_3
X_4026_ _3081_ _3127_ _3212_ _3115_ _3126_ VGND VGND VPWR VPWR _3213_ sky130_fd_sc_hd__a2111o_1
XFILLER_65_671 VGND VGND VPWR VPWR sky130_fd_sc_hd__fill_1
XFILLER_25_502 VGND VGND VPWR VPWR sky130_fd_sc_hd__fill_2
XFILLER_25_524 VPWR VGND VPWR VGND sky130_ef_sc_hd__decap_12
XFILLER_37_373 VGND VGND VPWR VPWR sky130_fd_sc_hd__decap_4
X_5977_ net462 net206 net199 net466 VGND VGND VPWR VPWR _1824_ sky130_fd_sc_hd__a22o_1
XFILLER_40_505 VGND VGND VPWR VPWR sky130_fd_sc_hd__fill_1
XFILLER_40_516 VGND VGND VPWR VPWR sky130_fd_sc_hd__fill_2
XFILLER_52_354 VGND VGND VPWR VPWR sky130_fd_sc_hd__decap_8
X_4928_ _0683_ _0685_ _0602_ VGND VGND VPWR VPWR _0687_ sky130_fd_sc_hd__a21o_1
XFILLER_20_251 VGND VGND VPWR VPWR sky130_fd_sc_hd__fill_1
X_4859_ _0470_ _0538_ _0539_ VGND VGND VPWR VPWR _0619_ sky130_fd_sc_hd__a21oi_1
XFILLER_106_301 VGND VGND VPWR VPWR sky130_fd_sc_hd__decap_6
X_6529_ _2384_ _2424_ _2425_ VGND VGND VPWR VPWR _2426_ sky130_fd_sc_hd__or3_1
XFILLER_106_356 VGND VGND VPWR VPWR sky130_fd_sc_hd__decap_8
XFILLER_0_601 VPWR VGND VPWR VGND sky130_ef_sc_hd__decap_12
XFILLER_0_645 VPWR VGND VPWR VGND sky130_ef_sc_hd__decap_12
XFILLER_87_240 VPWR VGND VPWR VGND sky130_ef_sc_hd__decap_12
XFILLER_102_584 VGND VGND VPWR VPWR sky130_fd_sc_hd__decap_4
XTAP_TAPCELL_ROW_89_1325 VGND VPWR sky130_fd_sc_hd__tapvpwrvgnd_1
XTAP_TAPCELL_ROW_89_1314 VGND VPWR sky130_fd_sc_hd__tapvpwrvgnd_1
XFILLER_85_57 VGND VGND VPWR VPWR sky130_fd_sc_hd__decap_6
XFILLER_75_457 VGND VGND VPWR VPWR sky130_fd_sc_hd__fill_2
XTAP_TAPCELL_ROW_46_806 VGND VPWR sky130_fd_sc_hd__tapvpwrvgnd_1
XFILLER_28_362 VGND VGND VPWR VPWR sky130_fd_sc_hd__fill_2
XFILLER_71_685 VGND VGND VPWR VPWR sky130_fd_sc_hd__fill_1
XTAP_TAPCELL_ROW_26_563 VGND VPWR sky130_fd_sc_hd__tapvpwrvgnd_1
XFILLER_70_195 VGND VGND VPWR VPWR sky130_fd_sc_hd__fill_1
XTAP_TAPCELL_ROW_54_894 VGND VPWR sky130_fd_sc_hd__tapvpwrvgnd_1
XFILLER_34_83 VGND VGND VPWR VPWR sky130_fd_sc_hd__fill_1
XFILLER_116_109 VGND VGND VPWR VPWR sky130_fd_sc_hd__decap_3
XFILLER_7_233 VGND VGND VPWR VPWR sky130_fd_sc_hd__fill_1
XFILLER_78_251 VGND VGND VPWR VPWR sky130_fd_sc_hd__fill_1
XFILLER_59_91 VGND VGND VPWR VPWR sky130_fd_sc_hd__decap_4
XFILLER_66_413 VGND VGND VPWR VPWR sky130_fd_sc_hd__decap_6
XFILLER_93_232 VGND VGND VPWR VPWR sky130_fd_sc_hd__fill_1
XFILLER_66_457 VGND VGND VPWR VPWR sky130_fd_sc_hd__decap_6
XFILLER_38_159 VPWR VGND VPWR VGND sky130_ef_sc_hd__decap_12
XTAP_TAPCELL_ROW_109_1561 VGND VPWR sky130_fd_sc_hd__tapvpwrvgnd_1
XFILLER_81_427 VGND VGND VPWR VPWR sky130_fd_sc_hd__fill_1
X_5900_ net395 net275 VGND VGND VPWR VPWR _1739_ sky130_fd_sc_hd__nand2_1
XFILLER_47_671 VGND VGND VPWR VPWR sky130_fd_sc_hd__fill_1
X_6880_ net184 _alu_i0.Datapath_i.fu_alu_33673_33851.out1\[6\] VGND VGND VPWR VPWR
+ _alu_i0.Datapath_i.reg_0.reg_out1\[6\] sky130_fd_sc_hd__dfxtp_1
XFILLER_81_449 VGND VGND VPWR VPWR sky130_fd_sc_hd__fill_1
XFILLER_34_365 VPWR VGND VPWR VGND sky130_ef_sc_hd__decap_12
X_5831_ net247 net446 _1527_ _1529_ net13 VGND VGND VPWR VPWR _1664_ sky130_fd_sc_hd__a32o_1
X_5762_ net468 net451 net267 net263 VGND VGND VPWR VPWR _1588_ sky130_fd_sc_hd__and4_1
X_4713_ _alu_i0.Datapath_i.reg_0.reg_out1\[12\] _0474_ net146 VGND VGND VPWR VPWR
+ net80 sky130_fd_sc_hd__mux2_1
X_5693_ _1509_ _1510_ _1511_ VGND VGND VPWR VPWR _1513_ sky130_fd_sc_hd__nand3_1
XFILLER_107_109 VGND VGND VPWR VPWR sky130_fd_sc_hd__decap_3
X_4644_ _0404_ _0405_ VGND VGND VPWR VPWR _0407_ sky130_fd_sc_hd__xnor2_1
XFILLER_116_621 VPWR VGND VPWR VGND sky130_ef_sc_hd__decap_12
XFILLER_116_610 VGND VGND VPWR VPWR sky130_fd_sc_hd__decap_6
X_4575_ _0278_ _0280_ VGND VGND VPWR VPWR _0339_ sky130_fd_sc_hd__and2b_1
XFILLER_89_505 VGND VGND VPWR VPWR sky130_fd_sc_hd__decap_8
X_3526_ net347 _0852_ _2073_ VGND VGND VPWR VPWR _2084_ sky130_fd_sc_hd__o21ai_1
X_6314_ _2020_ _2188_ VGND VGND VPWR VPWR _2190_ sky130_fd_sc_hd__xnor2_1
XFILLER_115_164 VGND VGND VPWR VPWR sky130_fd_sc_hd__fill_1
XFILLER_89_527 VPWR VGND VPWR VGND sky130_ef_sc_hd__decap_12
XTAP_TAPCELL_ROW_73_1126 VGND VPWR sky130_fd_sc_hd__tapvpwrvgnd_1
X_6245_ net247 net437 VGND VGND VPWR VPWR _2115_ sky130_fd_sc_hd__nand2_1
X_3457_ _1299_ _1321_ net282 VGND VGND VPWR VPWR _1332_ sky130_fd_sc_hd__mux2_1
XFILLER_39_39 VPWR VGND VPWR VGND sky130_ef_sc_hd__decap_12
XFILLER_69_262 VGND VGND VPWR VPWR sky130_fd_sc_hd__decap_3
X_6176_ net359 net296 net292 net367 VGND VGND VPWR VPWR _2039_ sky130_fd_sc_hd__a22oi_1
X_5127_ _0893_ _0894_ _0892_ VGND VGND VPWR VPWR _0896_ sky130_fd_sc_hd__a21o_1
X_5058_ _0709_ _0820_ VGND VGND VPWR VPWR _0821_ sky130_fd_sc_hd__nand2_1
XPHY_EDGE_ROW_2_Right_2 VGND VGND VPWR VPWR sky130_fd_sc_hd__decap_3
XFILLER_29_148 VGND VGND VPWR VPWR sky130_fd_sc_hd__decap_8
XFILLER_84_265 VPWR VGND VPWR VGND sky130_ef_sc_hd__decap_12
X_4009_ _1725_ _2827_ _2838_ _3135_ VGND VGND VPWR VPWR _3197_ sky130_fd_sc_hd__o22a_1
XFILLER_55_49 VGND VGND VPWR VPWR sky130_fd_sc_hd__decap_6
XFILLER_44_107 VGND VGND VPWR VPWR sky130_fd_sc_hd__decap_3
XFILLER_53_641 VPWR VGND VPWR VGND sky130_ef_sc_hd__decap_12
XFILLER_111_55 VGND VGND VPWR VPWR sky130_fd_sc_hd__fill_1
XTAP_TAPCELL_ROW_84_1255 VGND VPWR sky130_fd_sc_hd__tapvpwrvgnd_1
XFILLER_53_685 VGND VGND VPWR VPWR sky130_fd_sc_hd__decap_6
XFILLER_13_505 VGND VGND VPWR VPWR sky130_fd_sc_hd__decap_4
XFILLER_13_516 VGND VGND VPWR VPWR sky130_fd_sc_hd__decap_8
XFILLER_25_365 VGND VGND VPWR VPWR sky130_fd_sc_hd__fill_2
XFILLER_40_302 VGND VGND VPWR VPWR sky130_fd_sc_hd__decap_6
XFILLER_71_15 VPWR VGND VPWR VGND sky130_ef_sc_hd__decap_12
XTAP_TAPCELL_ROW_23_522 VGND VPWR sky130_fd_sc_hd__tapvpwrvgnd_1
XFILLER_40_335 VGND VGND VPWR VPWR sky130_fd_sc_hd__decap_4
XFILLER_52_195 VGND VGND VPWR VPWR sky130_fd_sc_hd__fill_1
XTAP_TAPCELL_ROW_23_533 VGND VPWR sky130_fd_sc_hd__tapvpwrvgnd_1
XFILLER_40_346 VPWR VGND VPWR VGND sky130_ef_sc_hd__decap_12
XTAP_TAPCELL_ROW_51_864 VGND VPWR sky130_fd_sc_hd__tapvpwrvgnd_1
XFILLER_112_3 VPWR VGND VPWR VGND sky130_ef_sc_hd__decap_12
XFILLER_107_665 VGND VGND VPWR VPWR sky130_fd_sc_hd__decap_6
XFILLER_106_120 VGND VGND VPWR VPWR sky130_fd_sc_hd__decap_8
XFILLER_20_41 VPWR VGND VPWR VGND sky130_ef_sc_hd__decap_12
XTAP_TAPCELL_ROW_95_1395 VGND VPWR sky130_fd_sc_hd__tapvpwrvgnd_1
XFILLER_20_85 VGND VGND VPWR VPWR sky130_fd_sc_hd__fill_1
XFILLER_106_197 VGND VGND VPWR VPWR sky130_fd_sc_hd__fill_2
XFILLER_96_78 VGND VGND VPWR VPWR sky130_fd_sc_hd__decap_6
XFILLER_95_519 VGND VGND VPWR VPWR sky130_fd_sc_hd__fill_1
XFILLER_0_442 VGND VGND VPWR VPWR sky130_fd_sc_hd__decap_6
XTAP_TAPCELL_ROW_59_964 VGND VPWR sky130_fd_sc_hd__tapvpwrvgnd_1
XFILLER_75_287 VGND VGND VPWR VPWR sky130_fd_sc_hd__decap_4
XFILLER_63_427 VGND VGND VPWR VPWR sky130_fd_sc_hd__decap_4
XFILLER_29_671 VGND VGND VPWR VPWR sky130_fd_sc_hd__fill_1
XFILLER_63_449 VPWR VGND VPWR VGND sky130_ef_sc_hd__decap_12
XTAP_TAPCELL_ROW_3_291 VGND VPWR sky130_fd_sc_hd__tapvpwrvgnd_1
XFILLER_16_321 VPWR VGND VPWR VGND sky130_ef_sc_hd__decap_12
XFILLER_16_365 VPWR VGND VPWR VGND sky130_ef_sc_hd__decap_12
XFILLER_45_60 VGND VGND VPWR VPWR sky130_fd_sc_hd__decap_3
XFILLER_71_482 VPWR VGND VPWR VGND sky130_ef_sc_hd__decap_12
XFILLER_8_531 VGND VGND VPWR VPWR sky130_fd_sc_hd__fill_1
XANTENNA_3 _3004_ VGND VGND VPWR VPWR sky130_fd_sc_hd__diode_2
X_4360_ _0125_ _0126_ _0127_ VGND VGND VPWR VPWR _0128_ sky130_fd_sc_hd__nand3_1
XFILLER_6_65 VPWR VGND VPWR VGND sky130_ef_sc_hd__decap_12
X_4291_ _0050_ _0061_ VGND VGND VPWR VPWR _0062_ sky130_fd_sc_hd__nand2_1
XFILLER_100_307 VGND VGND VPWR VPWR sky130_fd_sc_hd__fill_1
X_6030_ _1878_ _1879_ VGND VGND VPWR VPWR _1880_ sky130_fd_sc_hd__and2b_1
XFILLER_100_329 VGND VGND VPWR VPWR sky130_fd_sc_hd__fill_2
XFILLER_27_608 VGND VGND VPWR VPWR sky130_fd_sc_hd__decap_8
XFILLER_39_446 VGND VGND VPWR VPWR sky130_fd_sc_hd__fill_2
XFILLER_66_265 VPWR VGND VPWR VGND sky130_ef_sc_hd__decap_12
XFILLER_54_427 VGND VGND VPWR VPWR sky130_fd_sc_hd__fill_1
XFILLER_39_479 VGND VGND VPWR VPWR sky130_fd_sc_hd__fill_2
XFILLER_35_641 VPWR VGND VPWR VGND sky130_ef_sc_hd__decap_12
X_6863_ _2669_ _2789_ VGND VGND VPWR VPWR _2790_ sky130_fd_sc_hd__xnor2_1
XFILLER_34_151 VGND VGND VPWR VPWR sky130_fd_sc_hd__decap_4
X_5814_ _1640_ _1641_ _1642_ VGND VGND VPWR VPWR _1645_ sky130_fd_sc_hd__a21oi_1
XFILLER_35_685 VGND VGND VPWR VPWR sky130_fd_sc_hd__decap_6
XFILLER_22_346 VGND VGND VPWR VPWR sky130_fd_sc_hd__decap_8
X_6794_ _2710_ _2713_ VGND VGND VPWR VPWR _2714_ sky130_fd_sc_hd__xnor2_1
X_5745_ _1525_ _1526_ _1567_ _1568_ VGND VGND VPWR VPWR _1570_ sky130_fd_sc_hd__a22o_1
X_5676_ _3003_ _1405_ _1403_ VGND VGND VPWR VPWR _1494_ sky130_fd_sc_hd__a21o_1
X_4627_ _0389_ VGND VGND VPWR VPWR _0390_ sky130_fd_sc_hd__inv_2
XFILLER_116_473 VGND VGND VPWR VPWR sky130_fd_sc_hd__decap_3
X_4558_ _0320_ _0321_ VGND VGND VPWR VPWR _0322_ sky130_fd_sc_hd__xor2_1
XFILLER_104_613 VPWR VGND VPWR VGND sky130_ef_sc_hd__decap_12
X_4489_ net415 net217 _0189_ _0188_ VGND VGND VPWR VPWR _0254_ sky130_fd_sc_hd__a31o_1
XFILLER_104_657 VPWR VGND VPWR VGND sky130_ef_sc_hd__decap_12
XFILLER_89_324 VPWR VGND VPWR VGND sky130_ef_sc_hd__decap_12
X_3509_ net285 net456 VGND VGND VPWR VPWR _1898_ sky130_fd_sc_hd__xor2_2
XFILLER_103_156 VGND VGND VPWR VPWR sky130_fd_sc_hd__fill_1
X_6228_ _2093_ _2094_ _2086_ VGND VGND VPWR VPWR _2097_ sky130_fd_sc_hd__a21o_1
X_6159_ net470 net452 net254 net253 VGND VGND VPWR VPWR _2021_ sky130_fd_sc_hd__nand4_1
XFILLER_97_390 VGND VGND VPWR VPWR sky130_fd_sc_hd__fill_2
XFILLER_85_552 VGND VGND VPWR VPWR sky130_fd_sc_hd__decap_8
XFILLER_85_530 VPWR VGND VPWR VGND sky130_ef_sc_hd__decap_12
XFILLER_85_585 VPWR VGND VPWR VGND sky130_ef_sc_hd__decap_12
XFILLER_57_276 VGND VGND VPWR VPWR sky130_fd_sc_hd__decap_4
XTAP_TAPCELL_ROW_56_923 VGND VPWR sky130_fd_sc_hd__tapvpwrvgnd_1
XFILLER_45_405 VGND VGND VPWR VPWR sky130_fd_sc_hd__fill_2
XTAP_TAPCELL_ROW_0_250 VGND VPWR sky130_fd_sc_hd__tapvpwrvgnd_1
XFILLER_25_151 VPWR VGND VPWR VGND sky130_ef_sc_hd__decap_12
XFILLER_41_600 VPWR VGND VPWR VGND sky130_ef_sc_hd__decap_12
XTAP_TAPCELL_ROW_36_680 VGND VPWR sky130_fd_sc_hd__tapvpwrvgnd_1
XTAP_TAPCELL_ROW_97_1413 VGND VPWR sky130_fd_sc_hd__tapvpwrvgnd_1
XFILLER_31_51 VGND VGND VPWR VPWR sky130_fd_sc_hd__decap_4
Xoutput84 net84 VGND VGND VPWR VPWR return_port[16] sky130_fd_sc_hd__clkbuf_4
XTAP_TAPCELL_ROW_8_350 VGND VPWR sky130_fd_sc_hd__tapvpwrvgnd_1
XFILLER_95_327 VGND VGND VPWR VPWR sky130_fd_sc_hd__decap_6
Xoutput95 net95 VGND VGND VPWR VPWR return_port[26] sky130_fd_sc_hd__clkbuf_4
XFILLER_48_232 VPWR VGND VPWR VGND sky130_ef_sc_hd__decap_12
XFILLER_76_596 VGND VGND VPWR VPWR sky130_fd_sc_hd__fill_1
XTAP_TAPCELL_ROW_106_1520 VGND VPWR sky130_fd_sc_hd__tapvpwrvgnd_1
XFILLER_17_641 VPWR VGND VPWR VGND sky130_ef_sc_hd__decap_12
XFILLER_51_408 VGND VGND VPWR VPWR sky130_fd_sc_hd__fill_2
XFILLER_17_685 VGND VGND VPWR VPWR sky130_fd_sc_hd__decap_6
XFILLER_71_290 VGND VGND VPWR VPWR sky130_fd_sc_hd__decap_4
X_3860_ _3052_ _3053_ VGND VGND VPWR VPWR _3054_ sky130_fd_sc_hd__nor2_1
X_3791_ _0819_ net191 VGND VGND VPWR VPWR _2988_ sky130_fd_sc_hd__and2_1
XFILLER_72_91 VGND VGND VPWR VPWR sky130_fd_sc_hd__fill_2
XFILLER_75_3 VPWR VGND VPWR VGND sky130_ef_sc_hd__decap_12
X_5530_ _1333_ _1334_ net150 VGND VGND VPWR VPWR _1336_ sky130_fd_sc_hd__a21oi_1
X_5461_ net469 net453 net272 VGND VGND VPWR VPWR _1260_ sky130_fd_sc_hd__and3_1
X_4412_ _0133_ _0136_ VGND VGND VPWR VPWR _0179_ sky130_fd_sc_hd__nand2_1
X_5392_ _1182_ _1183_ VGND VGND VPWR VPWR _1185_ sky130_fd_sc_hd__xor2_1
XPHY_EDGE_ROW_99_Right_99 VGND VGND VPWR VPWR sky130_fd_sc_hd__decap_3
X_4343_ _0110_ _0111_ VGND VGND VPWR VPWR _0112_ sky130_fd_sc_hd__nand2_1
XFILLER_86_305 VGND VGND VPWR VPWR sky130_fd_sc_hd__decap_3
X_4274_ _1092_ _1855_ VGND VGND VPWR VPWR _0047_ sky130_fd_sc_hd__and2_1
Xfanout318 net39 VGND VGND VPWR VPWR net318 sky130_fd_sc_hd__clkbuf_4
Xfanout307 net40 VGND VGND VPWR VPWR net307 sky130_fd_sc_hd__buf_2
Xfanout329 net330 VGND VGND VPWR VPWR net329 sky130_fd_sc_hd__buf_2
X_6013_ _1719_ _1721_ _1723_ _1717_ _1716_ VGND VGND VPWR VPWR _1862_ sky130_fd_sc_hd__o32a_1
XFILLER_82_500 VPWR VGND VPWR VGND sky130_ef_sc_hd__decap_12
XFILLER_27_405 VGND VGND VPWR VPWR sky130_fd_sc_hd__decap_6
XFILLER_82_533 VPWR VGND VPWR VGND sky130_ef_sc_hd__decap_12
XPHY_EDGE_ROW_6_Left_123 VGND VGND VPWR VPWR sky130_fd_sc_hd__decap_3
XFILLER_27_438 VGND VGND VPWR VPWR sky130_fd_sc_hd__decap_3
XFILLER_36_29 VPWR VGND VPWR VGND sky130_ef_sc_hd__decap_12
XTAP_TAPCELL_ROW_68_1069 VGND VPWR sky130_fd_sc_hd__tapvpwrvgnd_1
XFILLER_54_279 VGND VGND VPWR VPWR sky130_fd_sc_hd__decap_3
XTAP_TAPCELL_ROW_81_1225 VGND VPWR sky130_fd_sc_hd__tapvpwrvgnd_1
XFILLER_23_611 VGND VGND VPWR VPWR sky130_fd_sc_hd__decap_4
XFILLER_35_493 VGND VGND VPWR VPWR sky130_fd_sc_hd__decap_8
XFILLER_22_121 VPWR VGND VPWR VGND sky130_ef_sc_hd__decap_12
X_6846_ _2766_ _2767_ _2768_ _2769_ VGND VGND VPWR VPWR _2771_ sky130_fd_sc_hd__a22o_1
XFILLER_50_452 VGND VGND VPWR VPWR sky130_fd_sc_hd__fill_1
XTAP_TAPCELL_ROW_61_981 VGND VPWR sky130_fd_sc_hd__tapvpwrvgnd_1
X_6777_ _2620_ _2626_ _2628_ VGND VGND VPWR VPWR _2696_ sky130_fd_sc_hd__a21oi_1
XTAP_TAPCELL_ROW_33_650 VGND VPWR sky130_fd_sc_hd__tapvpwrvgnd_1
XFILLER_50_463 VGND VGND VPWR VPWR sky130_fd_sc_hd__decap_4
XFILLER_50_474 VGND VGND VPWR VPWR sky130_fd_sc_hd__fill_2
XFILLER_50_485 VPWR VGND VPWR VGND sky130_ef_sc_hd__decap_12
X_3989_ net151 _2997_ _3177_ _0808_ VGND VGND VPWR VPWR _3178_ sky130_fd_sc_hd__o211a_1
X_5728_ _1548_ _1549_ _1545_ VGND VGND VPWR VPWR _1552_ sky130_fd_sc_hd__a21o_1
XFILLER_6_309 VGND VGND VPWR VPWR sky130_fd_sc_hd__fill_1
X_5659_ _1474_ _1475_ VGND VGND VPWR VPWR _1476_ sky130_fd_sc_hd__xnor2_1
XTAP_TAPCELL_ROW_79_1198 VGND VPWR sky130_fd_sc_hd__tapvpwrvgnd_1
XFILLER_116_270 VGND VGND VPWR VPWR sky130_fd_sc_hd__decap_8
XFILLER_104_421 VPWR VGND VPWR VGND sky130_ef_sc_hd__decap_12
XTAP_TAPCELL_ROW_92_1354 VGND VPWR sky130_fd_sc_hd__tapvpwrvgnd_1
XFILLER_89_121 VGND VGND VPWR VPWR sky130_fd_sc_hd__fill_2
XFILLER_89_110 VGND VGND VPWR VPWR sky130_fd_sc_hd__fill_2
XFILLER_77_316 VGND VGND VPWR VPWR sky130_fd_sc_hd__fill_1
XFILLER_58_530 VGND VGND VPWR VPWR sky130_fd_sc_hd__fill_2
XFILLER_58_585 VGND VGND VPWR VPWR sky130_fd_sc_hd__decap_3
XFILLER_93_57 VPWR VGND VPWR VGND sky130_ef_sc_hd__decap_12
XFILLER_85_393 VGND VGND VPWR VPWR sky130_fd_sc_hd__decap_4
XFILLER_45_279 VGND VGND VPWR VPWR sky130_fd_sc_hd__fill_1
XFILLER_13_110 VGND VGND VPWR VPWR sky130_fd_sc_hd__fill_2
XFILLER_13_154 VGND VGND VPWR VPWR sky130_fd_sc_hd__decap_6
XFILLER_41_485 VPWR VGND VPWR VGND sky130_ef_sc_hd__decap_12
XTAP_TAPCELL_ROW_101_1461 VGND VPWR sky130_fd_sc_hd__tapvpwrvgnd_1
XFILLER_9_147 VPWR VGND VPWR VGND sky130_ef_sc_hd__decap_12
XFILLER_42_50 VPWR VGND VPWR VGND sky130_ef_sc_hd__decap_12
XFILLER_9_169 VGND VGND VPWR VPWR sky130_fd_sc_hd__decap_3
XFILLER_42_72 VGND VGND VPWR VPWR sky130_fd_sc_hd__fill_1
XFILLER_42_94 VGND VGND VPWR VPWR sky130_fd_sc_hd__decap_8
XTAP_TAPCELL_ROW_11_388 VGND VPWR sky130_fd_sc_hd__tapvpwrvgnd_1
XFILLER_5_331 VGND VGND VPWR VPWR sky130_fd_sc_hd__fill_1
XFILLER_96_625 VPWR VGND VPWR VGND sky130_ef_sc_hd__decap_12
XFILLER_95_113 VGND VGND VPWR VPWR sky130_fd_sc_hd__decap_8
XFILLER_68_327 VPWR VGND VPWR VGND sky130_ef_sc_hd__decap_12
XFILLER_3_55 VGND VGND VPWR VPWR sky130_fd_sc_hd__fill_1
XTAP_TAPCELL_ROW_112_1590 VGND VPWR sky130_fd_sc_hd__tapvpwrvgnd_1
XFILLER_110_435 VGND VGND VPWR VPWR sky130_fd_sc_hd__fill_1
XFILLER_96_669 VPWR VGND VPWR VGND sky130_ef_sc_hd__decap_12
XFILLER_95_146 VPWR VGND VPWR VGND sky130_ef_sc_hd__decap_12
XPHY_EDGE_ROW_79_Left_196 VGND VGND VPWR VPWR sky130_fd_sc_hd__decap_3
XFILLER_83_308 VGND VGND VPWR VPWR sky130_fd_sc_hd__decap_8
XFILLER_67_80 VGND VGND VPWR VPWR sky130_fd_sc_hd__decap_4
XFILLER_64_533 VGND VGND VPWR VPWR sky130_fd_sc_hd__decap_8
XFILLER_36_224 VGND VGND VPWR VPWR sky130_fd_sc_hd__decap_3
XFILLER_91_341 VGND VGND VPWR VPWR sky130_fd_sc_hd__fill_1
XFILLER_91_385 VGND VGND VPWR VPWR sky130_fd_sc_hd__decap_6
X_4961_ _0717_ _0718_ _0716_ VGND VGND VPWR VPWR _0719_ sky130_fd_sc_hd__a21o_1
XTAP_TAPCELL_ROW_19_477 VGND VPWR sky130_fd_sc_hd__tapvpwrvgnd_1
XFILLER_51_216 VGND VGND VPWR VPWR sky130_fd_sc_hd__fill_2
X_4892_ _0649_ _0650_ _0648_ VGND VGND VPWR VPWR _0651_ sky130_fd_sc_hd__a21o_1
X_3912_ net164 net176 _2314_ VGND VGND VPWR VPWR _3104_ sky130_fd_sc_hd__a21bo_1
X_6700_ net277 net22 VGND VGND VPWR VPWR _2612_ sky130_fd_sc_hd__nand2_1
X_3843_ net123 _3035_ _3036_ _3037_ _3030_ VGND VGND VPWR VPWR _3038_ sky130_fd_sc_hd__a32o_1
XFILLER_20_625 VPWR VGND VPWR VGND sky130_ef_sc_hd__decap_12
X_6631_ net430 net274 VGND VGND VPWR VPWR _2536_ sky130_fd_sc_hd__nand2_1
X_3774_ _2139_ _2368_ net155 VGND VGND VPWR VPWR _2972_ sky130_fd_sc_hd__mux2_1
XFILLER_20_669 VPWR VGND VPWR VGND sky130_ef_sc_hd__decap_12
X_6562_ _2236_ _2239_ _2461_ VGND VGND VPWR VPWR _2462_ sky130_fd_sc_hd__o21a_1
X_5513_ _1314_ _1315_ _1191_ VGND VGND VPWR VPWR _1317_ sky130_fd_sc_hd__a21o_1
X_6493_ net460 net448 net185 net340 VGND VGND VPWR VPWR _2386_ sky130_fd_sc_hd__and4_1
X_5444_ _1239_ _1240_ _1232_ VGND VGND VPWR VPWR _1241_ sky130_fd_sc_hd__a21o_1
X_5375_ _1163_ _1164_ _1165_ VGND VGND VPWR VPWR _1166_ sky130_fd_sc_hd__and3_1
XFILLER_113_262 VGND VGND VPWR VPWR sky130_fd_sc_hd__fill_2
X_4326_ net238 net225 net454 net422 VGND VGND VPWR VPWR _0095_ sky130_fd_sc_hd__and4_1
XFILLER_86_102 VGND VGND VPWR VPWR sky130_fd_sc_hd__decap_6
Xfanout137 net139 VGND VGND VPWR VPWR net137 sky130_fd_sc_hd__clkbuf_4
Xfanout126 net127 VGND VGND VPWR VPWR net126 sky130_fd_sc_hd__clkbuf_4
XFILLER_101_435 VPWR VGND VPWR VGND sky130_ef_sc_hd__decap_12
XFILLER_86_135 VGND VGND VPWR VPWR sky130_fd_sc_hd__fill_1
Xfanout148 _0046_ VGND VGND VPWR VPWR net148 sky130_fd_sc_hd__buf_4
Xfanout159 net160 VGND VGND VPWR VPWR net159 sky130_fd_sc_hd__clkbuf_4
XFILLER_59_349 VGND VGND VPWR VPWR sky130_fd_sc_hd__decap_8
X_4257_ _0009_ _0011_ _0018_ VGND VGND VPWR VPWR _0032_ sky130_fd_sc_hd__o21ai_1
XFILLER_86_157 VGND VGND VPWR VPWR sky130_fd_sc_hd__decap_8
X_4188_ _2825_ _3308_ _3353_ net128 _3367_ VGND VGND VPWR VPWR _3368_ sky130_fd_sc_hd__o221a_1
XFILLER_95_691 VGND VGND VPWR VPWR sky130_fd_sc_hd__fill_1
XFILLER_82_363 VGND VGND VPWR VPWR sky130_fd_sc_hd__fill_1
XFILLER_55_566 VGND VGND VPWR VPWR sky130_fd_sc_hd__decap_6
XFILLER_82_374 VGND VGND VPWR VPWR sky130_fd_sc_hd__decap_4
XFILLER_63_16 VGND VGND VPWR VPWR sky130_fd_sc_hd__decap_8
XFILLER_23_430 VGND VGND VPWR VPWR sky130_fd_sc_hd__decap_3
X_6829_ net166 net320 VGND VGND VPWR VPWR _2753_ sky130_fd_sc_hd__nand2_1
XFILLER_109_502 VGND VGND VPWR VPWR sky130_fd_sc_hd__fill_2
XFILLER_10_135 VGND VGND VPWR VPWR sky130_fd_sc_hd__decap_4
XFILLER_7_629 VPWR VGND VPWR VGND sky130_ef_sc_hd__decap_12
XFILLER_6_117 VPWR VGND VPWR VGND sky130_ef_sc_hd__decap_12
XFILLER_12_53 VGND VGND VPWR VPWR sky130_fd_sc_hd__decap_8
XFILLER_12_97 VGND VGND VPWR VPWR sky130_fd_sc_hd__decap_6
XFILLER_5_3 VPWR VGND VPWR VGND sky130_ef_sc_hd__decap_12
XFILLER_78_625 VPWR VGND VPWR VGND sky130_ef_sc_hd__decap_12
XFILLER_77_113 VPWR VGND VPWR VGND sky130_ef_sc_hd__decap_12
XFILLER_78_669 VPWR VGND VPWR VGND sky130_ef_sc_hd__decap_12
XFILLER_93_617 VPWR VGND VPWR VGND sky130_ef_sc_hd__decap_12
XFILLER_46_511 VPWR VGND VPWR VGND sky130_ef_sc_hd__decap_12
XFILLER_46_533 VPWR VGND VPWR VGND sky130_ef_sc_hd__decap_12
XFILLER_73_341 VGND VGND VPWR VPWR sky130_fd_sc_hd__fill_1
XFILLER_46_599 VGND VGND VPWR VPWR sky130_fd_sc_hd__decap_6
XFILLER_61_569 VGND VGND VPWR VPWR sky130_fd_sc_hd__fill_1
XTAP_TAPCELL_ROW_16_447 VGND VPWR sky130_fd_sc_hd__tapvpwrvgnd_1
XTAP_TAPCELL_ROW_44_778 VGND VPWR sky130_fd_sc_hd__tapvpwrvgnd_1
XFILLER_41_293 VPWR VGND VPWR VGND sky130_ef_sc_hd__decap_12
XFILLER_115_505 VPWR VGND VPWR VGND sky130_ef_sc_hd__decap_12
X_3490_ _1659_ _1681_ net289 VGND VGND VPWR VPWR _1692_ sky130_fd_sc_hd__mux2_1
XFILLER_96_411 VGND VGND VPWR VPWR sky130_fd_sc_hd__decap_8
XPHY_EDGE_ROW_87_Left_204 VGND VGND VPWR VPWR sky130_fd_sc_hd__decap_3
X_5160_ _0824_ _0927_ _0929_ VGND VGND VPWR VPWR _0932_ sky130_fd_sc_hd__or3_1
XFILLER_69_614 VGND VGND VPWR VPWR sky130_fd_sc_hd__fill_2
XFILLER_38_3 VPWR VGND VPWR VGND sky130_ef_sc_hd__decap_12
X_5091_ _0854_ _0855_ _0850_ VGND VGND VPWR VPWR _0857_ sky130_fd_sc_hd__a21o_1
X_4111_ net270 _3269_ VGND VGND VPWR VPWR _3294_ sky130_fd_sc_hd__nor2_1
XFILLER_96_488 VPWR VGND VPWR VGND sky130_ef_sc_hd__decap_12
XFILLER_96_477 VGND VGND VPWR VPWR sky130_fd_sc_hd__decap_6
X_4042_ _3224_ _3227_ VGND VGND VPWR VPWR _3228_ sky130_fd_sc_hd__and2_1
XFILLER_110_298 VGND VGND VPWR VPWR sky130_fd_sc_hd__fill_1
XFILLER_77_691 VGND VGND VPWR VPWR sky130_fd_sc_hd__fill_1
XFILLER_37_511 VGND VGND VPWR VPWR sky130_fd_sc_hd__fill_2
XFILLER_83_149 VGND VGND VPWR VPWR sky130_fd_sc_hd__decap_4
XTAP_TAPCELL_ROW_65_1028 VGND VPWR sky130_fd_sc_hd__tapvpwrvgnd_1
XFILLER_64_363 VGND VGND VPWR VPWR sky130_fd_sc_hd__fill_1
X_5993_ _1650_ _1652_ _1837_ _1838_ VGND VGND VPWR VPWR _1840_ sky130_fd_sc_hd__a211oi_4
XFILLER_24_216 VGND VGND VPWR VPWR sky130_fd_sc_hd__decap_8
XFILLER_37_599 VPWR VGND VPWR VGND sky130_ef_sc_hd__decap_12
XPHY_EDGE_ROW_96_Left_213 VGND VGND VPWR VPWR sky130_fd_sc_hd__decap_3
X_4944_ _0700_ _0701_ VGND VGND VPWR VPWR _0702_ sky130_fd_sc_hd__nor2_1
X_4875_ _0630_ _0631_ _0632_ VGND VGND VPWR VPWR _0634_ sky130_fd_sc_hd__nand3_1
XFILLER_20_433 VPWR VGND VPWR VGND sky130_ef_sc_hd__decap_12
XFILLER_32_293 VGND VGND VPWR VPWR sky130_fd_sc_hd__fill_1
X_3826_ _2821_ _2830_ net151 VGND VGND VPWR VPWR _3022_ sky130_fd_sc_hd__mux2_1
X_6614_ _2510_ _2516_ VGND VGND VPWR VPWR _2517_ sky130_fd_sc_hd__xor2_1
X_3757_ net371 net378 net392 net400 net350 net279 VGND VGND VPWR VPWR _2956_ sky130_fd_sc_hd__mux4_1
XFILLER_20_477 VGND VGND VPWR VPWR sky130_fd_sc_hd__decap_8
X_6545_ _2272_ _2274_ VGND VGND VPWR VPWR _2443_ sky130_fd_sc_hd__nand2_1
X_3688_ _2062_ _2303_ _2357_ _2379_ net153 net159 VGND VGND VPWR VPWR _2890_ sky130_fd_sc_hd__mux4_1
XFILLER_3_109 VGND VGND VPWR VPWR sky130_fd_sc_hd__decap_3
X_6476_ net359 net274 VGND VGND VPWR VPWR _2367_ sky130_fd_sc_hd__nand2_1
XTAP_TAPCELL_ROW_76_1168 VGND VPWR sky130_fd_sc_hd__tapvpwrvgnd_1
X_5427_ _1219_ _1220_ VGND VGND VPWR VPWR _1223_ sky130_fd_sc_hd__xor2_1
XFILLER_58_27 VGND VGND VPWR VPWR sky130_fd_sc_hd__fill_1
X_5358_ _1145_ _1147_ VGND VGND VPWR VPWR _1148_ sky130_fd_sc_hd__and2b_1
XFILLER_99_293 VPWR VGND VPWR VGND sky130_ef_sc_hd__decap_12
X_4309_ _0077_ _0078_ VGND VGND VPWR VPWR _0079_ sky130_fd_sc_hd__nand2b_1
XFILLER_87_444 VGND VGND VPWR VPWR sky130_fd_sc_hd__decap_4
XFILLER_75_617 VPWR VGND VPWR VGND sky130_ef_sc_hd__decap_12
XFILLER_75_606 VGND VGND VPWR VPWR sky130_fd_sc_hd__decap_8
X_5289_ _1058_ _1072_ VGND VGND VPWR VPWR _1073_ sky130_fd_sc_hd__nand2_1
XFILLER_101_287 VGND VGND VPWR VPWR sky130_fd_sc_hd__fill_1
XFILLER_114_77 VGND VGND VPWR VPWR sky130_fd_sc_hd__decap_6
XFILLER_43_503 VGND VGND VPWR VPWR sky130_fd_sc_hd__fill_1
XTAP_TAPCELL_ROW_87_1297 VGND VPWR sky130_fd_sc_hd__tapvpwrvgnd_1
XFILLER_70_377 VGND VGND VPWR VPWR sky130_fd_sc_hd__decap_3
XTAP_TAPCELL_ROW_13_406 VGND VPWR sky130_fd_sc_hd__tapvpwrvgnd_1
XFILLER_23_260 VPWR VGND VPWR VGND sky130_ef_sc_hd__decap_12
XTAP_TAPCELL_ROW_41_748 VGND VPWR sky130_fd_sc_hd__tapvpwrvgnd_1
XFILLER_11_466 VPWR VGND VPWR VGND sky130_ef_sc_hd__decap_12
XFILLER_23_63 VGND VGND VPWR VPWR sky130_fd_sc_hd__fill_1
XFILLER_23_293 VPWR VGND VPWR VGND sky130_ef_sc_hd__decap_12
XFILLER_99_67 VGND VGND VPWR VPWR sky130_fd_sc_hd__fill_1
XFILLER_97_208 VGND VGND VPWR VPWR sky130_fd_sc_hd__decap_4
XFILLER_3_665 VGND VGND VPWR VPWR sky130_fd_sc_hd__decap_6
XFILLER_78_477 VPWR VGND VPWR VGND sky130_ef_sc_hd__decap_12
XFILLER_93_447 VGND VGND VPWR VPWR sky130_fd_sc_hd__fill_1
XTAP_TAPCELL_ROW_49_837 VGND VPWR sky130_fd_sc_hd__tapvpwrvgnd_1
XFILLER_93_458 VGND VGND VPWR VPWR sky130_fd_sc_hd__fill_2
XFILLER_34_503 VGND VGND VPWR VPWR sky130_fd_sc_hd__fill_1
XFILLER_73_193 VGND VGND VPWR VPWR sky130_fd_sc_hd__decap_4
XFILLER_64_70 VGND VGND VPWR VPWR sky130_fd_sc_hd__decap_4
XTAP_TAPCELL_ROW_29_594 VGND VPWR sky130_fd_sc_hd__tapvpwrvgnd_1
X_4660_ net240 net228 net371 net362 VGND VGND VPWR VPWR _0422_ sky130_fd_sc_hd__nand4_1
X_3611_ _2808_ _2814_ VGND VGND VPWR VPWR _2815_ sky130_fd_sc_hd__nand2_1
XFILLER_9_98 VGND VGND VPWR VPWR sky130_fd_sc_hd__decap_6
X_4591_ net291 net362 _0305_ _0303_ VGND VGND VPWR VPWR _0354_ sky130_fd_sc_hd__a31o_1
X_6330_ _2206_ _2207_ VGND VGND VPWR VPWR _2208_ sky130_fd_sc_hd__xnor2_1
X_3542_ _2248_ VGND VGND VPWR VPWR _2259_ sky130_fd_sc_hd__inv_2
X_3473_ _1473_ _1495_ net278 VGND VGND VPWR VPWR _1506_ sky130_fd_sc_hd__mux2_1
X_6261_ _2132_ VGND VGND VPWR VPWR _2133_ sky130_fd_sc_hd__inv_2
XFILLER_115_379 VGND VGND VPWR VPWR sky130_fd_sc_hd__fill_2
XFILLER_88_219 VPWR VGND VPWR VGND sky130_ef_sc_hd__decap_12
X_5212_ _0986_ _0987_ _0844_ _0846_ VGND VGND VPWR VPWR _0989_ sky130_fd_sc_hd__a211o_1
X_6192_ _2054_ _2055_ _2045_ VGND VGND VPWR VPWR _2057_ sky130_fd_sc_hd__a21o_1
X_5143_ net262 net215 _0911_ _0912_ VGND VGND VPWR VPWR _0913_ sky130_fd_sc_hd__a22o_1
XFILLER_111_541 VPWR VGND VPWR VGND sky130_ef_sc_hd__decap_12
XFILLER_111_585 VPWR VGND VPWR VGND sky130_ef_sc_hd__decap_12
X_5074_ net252 net221 _0736_ _0734_ VGND VGND VPWR VPWR _0838_ sky130_fd_sc_hd__a31o_1
XTAP_TAPCELL_ROW_71_1098 VGND VPWR sky130_fd_sc_hd__tapvpwrvgnd_1
X_4025_ _3143_ _3162_ _3185_ VGND VGND VPWR VPWR _3212_ sky130_fd_sc_hd__or3_1
XFILLER_64_182 VGND VGND VPWR VPWR sky130_fd_sc_hd__decap_8
XFILLER_64_171 VGND VGND VPWR VPWR sky130_fd_sc_hd__decap_8
XFILLER_25_536 VGND VGND VPWR VPWR sky130_fd_sc_hd__fill_1
XFILLER_44_29 VPWR VGND VPWR VGND sky130_ef_sc_hd__decap_12
X_5976_ net466 net462 net206 net199 VGND VGND VPWR VPWR _1822_ sky130_fd_sc_hd__nand4_2
X_4927_ _0602_ _0683_ _0685_ VGND VGND VPWR VPWR _0686_ sky130_fd_sc_hd__nand3_1
X_4858_ _0470_ _0538_ _0539_ VGND VGND VPWR VPWR _0618_ sky130_fd_sc_hd__a21o_1
XFILLER_60_17 VGND VGND VPWR VPWR sky130_fd_sc_hd__fill_1
X_3809_ _3001_ _3003_ VGND VGND VPWR VPWR _3005_ sky130_fd_sc_hd__nor2_1
XFILLER_20_274 VGND VGND VPWR VPWR sky130_fd_sc_hd__fill_1
X_4789_ net417 net338 VGND VGND VPWR VPWR _0549_ sky130_fd_sc_hd__and2_1
XFILLER_109_55 VGND VGND VPWR VPWR sky130_fd_sc_hd__fill_1
XFILLER_4_418 VGND VGND VPWR VPWR sky130_fd_sc_hd__fill_2
X_6528_ _2252_ _2254_ _2422_ VGND VGND VPWR VPWR _2425_ sky130_fd_sc_hd__nor3_1
X_6459_ _2347_ _2348_ VGND VGND VPWR VPWR _2349_ sky130_fd_sc_hd__xnor2_1
XFILLER_0_613 VGND VGND VPWR VPWR sky130_fd_sc_hd__decap_3
XFILLER_114_390 VPWR VGND VPWR VGND sky130_ef_sc_hd__decap_12
XFILLER_87_252 VGND VGND VPWR VPWR sky130_fd_sc_hd__decap_4
XFILLER_0_657 VPWR VGND VPWR VGND sky130_ef_sc_hd__decap_12
XTAP_TAPCELL_ROW_89_1315 VGND VPWR sky130_fd_sc_hd__tapvpwrvgnd_1
XFILLER_75_425 VGND VGND VPWR VPWR sky130_fd_sc_hd__fill_2
XFILLER_18_41 VPWR VGND VPWR VGND sky130_ef_sc_hd__decap_12
XTAP_TAPCELL_ROW_46_807 VGND VPWR sky130_fd_sc_hd__tapvpwrvgnd_1
XFILLER_18_85 VPWR VGND VPWR VGND sky130_ef_sc_hd__decap_12
XTAP_TAPCELL_ROW_26_564 VGND VPWR sky130_fd_sc_hd__tapvpwrvgnd_1
XTAP_TAPCELL_ROW_54_895 VGND VPWR sky130_fd_sc_hd__tapvpwrvgnd_1
XFILLER_7_278 VGND VGND VPWR VPWR sky130_fd_sc_hd__fill_2
XFILLER_112_316 VGND VGND VPWR VPWR sky130_fd_sc_hd__decap_4
XFILLER_3_462 VGND VGND VPWR VPWR sky130_fd_sc_hd__decap_4
XFILLER_3_484 VPWR VGND VPWR VGND sky130_ef_sc_hd__decap_12
XFILLER_59_81 VGND VGND VPWR VPWR sky130_fd_sc_hd__decap_4
XFILLER_39_617 VPWR VGND VPWR VGND sky130_ef_sc_hd__decap_12
XFILLER_66_436 VPWR VGND VPWR VGND sky130_ef_sc_hd__decap_12
XFILLER_54_609 VGND VGND VPWR VPWR sky130_fd_sc_hd__decap_3
XTAP_TAPCELL_ROW_109_1562 VGND VPWR sky130_fd_sc_hd__tapvpwrvgnd_1
XFILLER_22_517 VPWR VGND VPWR VGND sky130_ef_sc_hd__decap_12
XFILLER_34_377 VPWR VGND VPWR VGND sky130_ef_sc_hd__decap_12
X_5830_ _1661_ _1662_ VGND VGND VPWR VPWR _1663_ sky130_fd_sc_hd__xnor2_1
X_5761_ net453 net267 net263 net469 VGND VGND VPWR VPWR _1587_ sky130_fd_sc_hd__a22oi_1
XFILLER_22_539 VPWR VGND VPWR VGND sky130_ef_sc_hd__decap_12
X_4712_ _0472_ _0473_ VGND VGND VPWR VPWR _0474_ sky130_fd_sc_hd__xnor2_1
X_5692_ _1509_ _1510_ _1511_ VGND VGND VPWR VPWR _1512_ sky130_fd_sc_hd__and3_1
X_4643_ _0338_ _0339_ _0402_ VGND VGND VPWR VPWR _0406_ sky130_fd_sc_hd__or3_1
X_4574_ _0289_ _0336_ VGND VGND VPWR VPWR _0338_ sky130_fd_sc_hd__xor2_1
XFILLER_116_633 VGND VGND VPWR VPWR sky130_fd_sc_hd__decap_8
X_3525_ net351 net443 VGND VGND VPWR VPWR _2073_ sky130_fd_sc_hd__nand2_2
X_6313_ _2020_ _2188_ VGND VGND VPWR VPWR _2189_ sky130_fd_sc_hd__nand2_1
XFILLER_89_539 VPWR VGND VPWR VGND sky130_ef_sc_hd__decap_12
XTAP_TAPCELL_ROW_73_1127 VGND VPWR sky130_fd_sc_hd__tapvpwrvgnd_1
X_6244_ _2112_ _2113_ VGND VGND VPWR VPWR _2114_ sky130_fd_sc_hd__nor2_1
X_3456_ net165 net465 _1310_ VGND VGND VPWR VPWR _1321_ sky130_fd_sc_hd__a21bo_1
XFILLER_97_561 VPWR VGND VPWR VGND sky130_ef_sc_hd__decap_12
X_6175_ net367 net359 net296 net292 VGND VGND VPWR VPWR _2038_ sky130_fd_sc_hd__and4_1
X_5126_ net224 net221 net177 net236 VGND VGND VPWR VPWR _0894_ sky130_fd_sc_hd__a22o_1
XFILLER_69_274 VGND VGND VPWR VPWR sky130_fd_sc_hd__decap_6
XFILLER_111_393 VPWR VGND VPWR VGND sky130_ef_sc_hd__decap_12
X_5057_ _0816_ _0817_ VGND VGND VPWR VPWR _0820_ sky130_fd_sc_hd__xor2_1
XFILLER_84_277 VGND VGND VPWR VPWR sky130_fd_sc_hd__decap_3
X_4008_ net152 _3019_ _3195_ net121 VGND VGND VPWR VPWR _3196_ sky130_fd_sc_hd__o211a_1
XFILLER_65_491 VGND VGND VPWR VPWR sky130_fd_sc_hd__decap_6
XTAP_TAPCELL_ROW_84_1256 VGND VPWR sky130_fd_sc_hd__tapvpwrvgnd_1
XFILLER_53_653 VPWR VGND VPWR VGND sky130_ef_sc_hd__decap_12
XFILLER_52_141 VPWR VGND VPWR VGND sky130_ef_sc_hd__decap_12
XFILLER_71_27 VPWR VGND VPWR VGND sky130_ef_sc_hd__decap_12
XTAP_TAPCELL_ROW_23_523 VGND VPWR sky130_fd_sc_hd__tapvpwrvgnd_1
X_5959_ _1802_ _1803_ VGND VGND VPWR VPWR _1804_ sky130_fd_sc_hd__and2b_1
XFILLER_40_358 VGND VGND VPWR VPWR sky130_fd_sc_hd__decap_6
XTAP_TAPCELL_ROW_51_865 VGND VPWR sky130_fd_sc_hd__tapvpwrvgnd_1
XFILLER_105_3 VPWR VGND VPWR VGND sky130_ef_sc_hd__decap_12
XTAP_TAPCELL_ROW_95_1396 VGND VPWR sky130_fd_sc_hd__tapvpwrvgnd_1
XFILLER_20_53 VPWR VGND VPWR VGND sky130_ef_sc_hd__decap_12
XFILLER_0_421 VPWR VGND VPWR VGND sky130_ef_sc_hd__decap_12
XFILLER_29_51 VGND VGND VPWR VPWR sky130_fd_sc_hd__decap_4
XPHY_EDGE_ROW_42_Left_159 VGND VGND VPWR VPWR sky130_fd_sc_hd__decap_3
XFILLER_102_393 VGND VGND VPWR VPWR sky130_fd_sc_hd__decap_3
XTAP_TAPCELL_ROW_59_965 VGND VPWR sky130_fd_sc_hd__tapvpwrvgnd_1
XTAP_TAPCELL_ROW_59_954 VGND VPWR sky130_fd_sc_hd__tapvpwrvgnd_1
XFILLER_36_609 VPWR VGND VPWR VGND sky130_ef_sc_hd__decap_12
XTAP_TAPCELL_ROW_3_292 VGND VPWR sky130_fd_sc_hd__tapvpwrvgnd_1
XFILLER_16_333 VPWR VGND VPWR VGND sky130_ef_sc_hd__decap_12
XFILLER_16_377 VGND VGND VPWR VPWR sky130_fd_sc_hd__fill_2
XFILLER_91_9 VPWR VGND VPWR VGND sky130_ef_sc_hd__decap_12
XPHY_EDGE_ROW_51_Left_168 VGND VGND VPWR VPWR sky130_fd_sc_hd__decap_3
XFILLER_61_82 VGND VGND VPWR VPWR sky130_fd_sc_hd__decap_8
XFILLER_8_587 VGND VGND VPWR VPWR sky130_fd_sc_hd__fill_1
XANTENNA_4 a[24] VGND VGND VPWR VPWR sky130_fd_sc_hd__diode_2
XFILLER_6_77 VGND VGND VPWR VPWR sky130_fd_sc_hd__decap_6
X_4290_ _0058_ _0059_ VGND VGND VPWR VPWR _0061_ sky130_fd_sc_hd__xnor2_1
XFILLER_3_281 VPWR VGND VPWR VGND sky130_ef_sc_hd__decap_12
XFILLER_79_561 VGND VGND VPWR VPWR sky130_fd_sc_hd__decap_8
XPHY_EDGE_ROW_60_Left_177 VGND VGND VPWR VPWR sky130_fd_sc_hd__decap_3
XFILLER_20_3 VPWR VGND VPWR VGND sky130_ef_sc_hd__decap_12
XFILLER_66_277 VPWR VGND VPWR VGND sky130_ef_sc_hd__decap_12
X_6862_ _2786_ _2788_ VGND VGND VPWR VPWR _2789_ sky130_fd_sc_hd__xnor2_1
XFILLER_34_141 VGND VGND VPWR VPWR sky130_fd_sc_hd__decap_6
XFILLER_35_653 VPWR VGND VPWR VGND sky130_ef_sc_hd__decap_12
XFILLER_50_601 VPWR VGND VPWR VGND sky130_ef_sc_hd__decap_12
X_5813_ _1640_ _1641_ _1642_ VGND VGND VPWR VPWR _1644_ sky130_fd_sc_hd__nand3_1
X_6793_ _2711_ _2712_ VGND VGND VPWR VPWR _2713_ sky130_fd_sc_hd__xor2_1
XFILLER_50_645 VPWR VGND VPWR VGND sky130_ef_sc_hd__decap_12
XFILLER_10_509 VGND VGND VPWR VPWR sky130_fd_sc_hd__decap_6
X_5744_ _1525_ _1526_ _1567_ _1568_ VGND VGND VPWR VPWR _1569_ sky130_fd_sc_hd__nand4_2
XFILLER_50_689 VGND VGND VPWR VPWR sky130_fd_sc_hd__decap_3
X_5675_ _1489_ _1490_ _1491_ VGND VGND VPWR VPWR _1493_ sky130_fd_sc_hd__o21ai_1
X_4626_ _0351_ _0387_ _0388_ VGND VGND VPWR VPWR _0389_ sky130_fd_sc_hd__or3_2
X_4557_ _0192_ _0193_ _0262_ _0260_ VGND VGND VPWR VPWR _0321_ sky130_fd_sc_hd__a31oi_1
XFILLER_104_625 VPWR VGND VPWR VGND sky130_ef_sc_hd__decap_12
XFILLER_103_113 VPWR VGND VPWR VGND sky130_ef_sc_hd__decap_12
X_4488_ net358 net363 _0250_ _0251_ VGND VGND VPWR VPWR _0253_ sky130_fd_sc_hd__nand4_2
X_3508_ net66 _1212_ VGND VGND VPWR VPWR _1887_ sky130_fd_sc_hd__or2_4
XFILLER_104_669 VPWR VGND VPWR VGND sky130_ef_sc_hd__decap_12
X_3439_ _1113_ _1124_ VGND VGND VPWR VPWR _1135_ sky130_fd_sc_hd__nor2_1
X_6227_ _2086_ _2093_ _2094_ VGND VGND VPWR VPWR _2096_ sky130_fd_sc_hd__nand3_2
X_6158_ net468 net451 net254 net253 VGND VGND VPWR VPWR _2020_ sky130_fd_sc_hd__and4_1
X_5109_ _0873_ _0875_ _0774_ VGND VGND VPWR VPWR _0877_ sky130_fd_sc_hd__o21ai_2
XFILLER_85_542 VGND VGND VPWR VPWR sky130_fd_sc_hd__decap_3
XFILLER_66_49 VGND VGND VPWR VPWR sky130_fd_sc_hd__decap_4
XFILLER_57_222 VGND VGND VPWR VPWR sky130_fd_sc_hd__fill_2
XTAP_TAPCELL_ROW_56_924 VGND VPWR sky130_fd_sc_hd__tapvpwrvgnd_1
X_6089_ _1901_ _1902_ _1941_ _1943_ VGND VGND VPWR VPWR _1945_ sky130_fd_sc_hd__or4bb_1
XFILLER_85_597 VPWR VGND VPWR VGND sky130_ef_sc_hd__decap_12
XFILLER_72_214 VGND VGND VPWR VPWR sky130_fd_sc_hd__decap_8
XFILLER_82_15 VPWR VGND VPWR VGND sky130_ef_sc_hd__decap_12
XTAP_TAPCELL_ROW_0_240 VGND VPWR sky130_fd_sc_hd__tapvpwrvgnd_1
XTAP_TAPCELL_ROW_0_251 VGND VPWR sky130_fd_sc_hd__tapvpwrvgnd_1
XFILLER_25_163 VGND VGND VPWR VPWR sky130_fd_sc_hd__decap_4
XTAP_TAPCELL_ROW_36_681 VGND VPWR sky130_fd_sc_hd__tapvpwrvgnd_1
XFILLER_41_612 VGND VGND VPWR VPWR sky130_fd_sc_hd__decap_4
XFILLER_9_329 VGND VGND VPWR VPWR sky130_fd_sc_hd__fill_1
XTAP_TAPCELL_ROW_97_1414 VGND VPWR sky130_fd_sc_hd__tapvpwrvgnd_1
XFILLER_107_441 VGND VGND VPWR VPWR sky130_fd_sc_hd__decap_6
Xoutput85 net85 VGND VGND VPWR VPWR return_port[17] sky130_fd_sc_hd__clkbuf_4
XTAP_TAPCELL_ROW_8_351 VGND VPWR sky130_fd_sc_hd__tapvpwrvgnd_1
Xoutput96 net96 VGND VGND VPWR VPWR return_port[27] sky130_fd_sc_hd__clkbuf_4
XFILLER_103_691 VGND VGND VPWR VPWR sky130_fd_sc_hd__fill_1
XFILLER_76_531 VGND VGND VPWR VPWR sky130_fd_sc_hd__fill_1
XFILLER_0_284 VPWR VGND VPWR VGND sky130_ef_sc_hd__decap_12
XFILLER_48_244 VGND VGND VPWR VPWR sky130_fd_sc_hd__decap_8
XTAP_TAPCELL_ROW_106_1521 VGND VPWR sky130_fd_sc_hd__tapvpwrvgnd_1
XFILLER_63_225 VGND VGND VPWR VPWR sky130_fd_sc_hd__decap_8
XFILLER_56_93 VGND VGND VPWR VPWR sky130_fd_sc_hd__fill_1
XFILLER_16_141 VPWR VGND VPWR VGND sky130_ef_sc_hd__decap_12
XFILLER_17_653 VPWR VGND VPWR VGND sky130_ef_sc_hd__decap_12
XFILLER_32_601 VPWR VGND VPWR VGND sky130_ef_sc_hd__decap_12
XFILLER_31_111 VGND VGND VPWR VPWR sky130_fd_sc_hd__fill_1
XFILLER_32_645 VPWR VGND VPWR VGND sky130_ef_sc_hd__decap_12
X_3790_ _2985_ _2986_ VGND VGND VPWR VPWR _2987_ sky130_fd_sc_hd__nor2_1
XFILLER_32_689 VGND VGND VPWR VPWR sky130_fd_sc_hd__decap_3
X_5460_ net453 net275 net272 net469 VGND VGND VPWR VPWR _1259_ sky130_fd_sc_hd__a22oi_1
X_4411_ _0141_ _0176_ VGND VGND VPWR VPWR _0178_ sky130_fd_sc_hd__xnor2_1
X_5391_ _1183_ _1182_ VGND VGND VPWR VPWR _1184_ sky130_fd_sc_hd__and2b_1
X_4342_ net355 net406 _0083_ _0082_ VGND VGND VPWR VPWR _0111_ sky130_fd_sc_hd__a31o_1
X_4273_ _alu_i0.Datapath_i.reg_0.reg_out1\[0\] _1092_ net148 VGND VGND VPWR VPWR net77
+ sky130_fd_sc_hd__mux2_1
Xfanout319 net320 VGND VGND VPWR VPWR net319 sky130_fd_sc_hd__clkbuf_4
Xfanout308 net40 VGND VGND VPWR VPWR net308 sky130_fd_sc_hd__clkbuf_2
XFILLER_101_617 VPWR VGND VPWR VGND sky130_ef_sc_hd__decap_12
X_6012_ _1859_ _1860_ VGND VGND VPWR VPWR _1861_ sky130_fd_sc_hd__nor2_1
.ends
